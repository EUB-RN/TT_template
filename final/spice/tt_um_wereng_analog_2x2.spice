* NGSPICE file created from tt_um_wereng_analog_2x2.ext - technology: sky130A

* Black-box entry subcircuit for sky130_fd_sc_hd__decap_3 abstract view
.subckt sky130_fd_sc_hd__decap_3 VGND VNB VPB VPWR
.ends

* Black-box entry subcircuit for sky130_fd_sc_hd__nor3b_1 abstract view
.subckt sky130_fd_sc_hd__nor3b_1 A B C_N VGND VNB VPB VPWR Y
.ends

* Black-box entry subcircuit for sky130_fd_sc_hd__a21oi_1 abstract view
.subckt sky130_fd_sc_hd__a21oi_1 A1 A2 B1 VGND VNB VPB VPWR Y
.ends

* Black-box entry subcircuit for dlxtp8_x1 abstract view
.subckt dlxtp8_x1 D0 D1 D2 D3 D4 D5 D6 D7 GATE VGND VPWR Q0 Q1 Q2 Q3 Q4 Q5 Q6 Q7
.ends

* Black-box entry subcircuit for sky130_fd_sc_hd__clkbuf_2 abstract view
.subckt sky130_fd_sc_hd__clkbuf_2 A VGND VNB VPB VPWR X
.ends

* Black-box entry subcircuit for sky130_fd_sc_hd__fill_2 abstract view
.subckt sky130_fd_sc_hd__fill_2 VGND VNB VPB VPWR
.ends

* Black-box entry subcircuit for sky130_fd_sc_hd__nand2_1 abstract view
.subckt sky130_fd_sc_hd__nand2_1 A B VGND VNB VPB VPWR Y
.ends

* Black-box entry subcircuit for sky130_fd_sc_hd__nor2_1 abstract view
.subckt sky130_fd_sc_hd__nor2_1 A B VGND VNB VPB VPWR Y
.ends

* Black-box entry subcircuit for sky130_fd_sc_hd__nand3_1 abstract view
.subckt sky130_fd_sc_hd__nand3_1 A B C VGND VNB VPB VPWR Y
.ends

* Black-box entry subcircuit for sky130_fd_sc_hd__dlclkp_1 abstract view
.subckt sky130_fd_sc_hd__dlclkp_1 CLK GATE VGND VNB VPB VPWR GCLK
.ends

* Black-box entry subcircuit for sky130_fd_sc_hd__fill_1 abstract view
.subckt sky130_fd_sc_hd__fill_1 VGND VNB VPB VPWR
.ends

* Black-box entry subcircuit for sky130_fd_sc_hd__or2_1 abstract view
.subckt sky130_fd_sc_hd__or2_1 A B VGND VNB VPB VPWR X
.ends

* Black-box entry subcircuit for sky130_fd_sc_hd__nor2b_1 abstract view
.subckt sky130_fd_sc_hd__nor2b_1 A B_N VGND VNB VPB VPWR Y
.ends

* Black-box entry subcircuit for sky130_fd_sc_hd__tapvpwrvgnd_1 abstract view
.subckt sky130_fd_sc_hd__tapvpwrvgnd_1 VGND VPWR
.ends

* Black-box entry subcircuit for sky130_fd_sc_hd__buf_4 abstract view
.subckt sky130_fd_sc_hd__buf_4 A VGND VNB VPB VPWR X
.ends

* Black-box entry subcircuit for sky130_fd_sc_hd__o21ai_1 abstract view
.subckt sky130_fd_sc_hd__o21ai_1 A1 A2 B1 VGND VNB VPB VPWR Y
.ends

* Black-box entry subcircuit for sky130_fd_sc_hd__dfxtp_1 abstract view
.subckt sky130_fd_sc_hd__dfxtp_1 CLK D VGND VNB VPB VPWR Q
.ends

* Black-box entry subcircuit for sky130_fd_sc_hd__o211ai_1 abstract view
.subckt sky130_fd_sc_hd__o211ai_1 A1 A2 B1 C1 VGND VNB VPB VPWR Y
.ends

* Black-box entry subcircuit for sky130_fd_sc_hd__and3_1 abstract view
.subckt sky130_fd_sc_hd__and3_1 A B C VGND VNB VPB VPWR X
.ends

* Black-box entry subcircuit for sky130_fd_sc_hd__mux2_1 abstract view
.subckt sky130_fd_sc_hd__mux2_1 A0 A1 S VGND VNB VPB VPWR X
.ends

* Black-box entry subcircuit for sky130_fd_sc_hd__nor3_1 abstract view
.subckt sky130_fd_sc_hd__nor3_1 A B C VGND VNB VPB VPWR Y
.ends

* Black-box entry subcircuit for sky130_fd_sc_hd__clkbuf_8 abstract view
.subckt sky130_fd_sc_hd__clkbuf_8 A VGND VNB VPB VPWR X
.ends

* Black-box entry subcircuit for sky130_fd_sc_hd__nand4_1 abstract view
.subckt sky130_fd_sc_hd__nand4_1 A B C D VGND VNB VPB VPWR Y
.ends

* Black-box entry subcircuit for sky130_fd_sc_hd__nand2b_1 abstract view
.subckt sky130_fd_sc_hd__nand2b_1 A_N B VGND VNB VPB VPWR Y
.ends

* Black-box entry subcircuit for sky130_fd_sc_hd__a211o_1 abstract view
.subckt sky130_fd_sc_hd__a211o_1 A1 A2 B1 C1 VGND VNB VPB VPWR X
.ends

* Black-box entry subcircuit for sky130_fd_sc_hd__dlygate4sd3_1 abstract view
.subckt sky130_fd_sc_hd__dlygate4sd3_1 A VGND VNB VPB VPWR X
.ends

* Black-box entry subcircuit for sky130_fd_sc_hd__diode_2 abstract view
.subckt sky130_fd_sc_hd__diode_2 DIODE VGND VNB VPB VPWR
.ends

* Black-box entry subcircuit for sky130_fd_sc_hd__a31oi_1 abstract view
.subckt sky130_fd_sc_hd__a31oi_1 A1 A2 A3 B1 VGND VNB VPB VPWR Y
.ends

* Black-box entry subcircuit for sky130_fd_sc_hd__a32oi_1 abstract view
.subckt sky130_fd_sc_hd__a32oi_1 A1 A2 A3 B1 B2 VGND VNB VPB VPWR Y
.ends

* Black-box entry subcircuit for sky130_fd_sc_hd__nor4_1 abstract view
.subckt sky130_fd_sc_hd__nor4_1 A B C D VGND VNB VPB VPWR Y
.ends

* Black-box entry subcircuit for sky130_fd_sc_hd__o22ai_1 abstract view
.subckt sky130_fd_sc_hd__o22ai_1 A1 A2 B1 B2 VGND VNB VPB VPWR Y
.ends

* Black-box entry subcircuit for sky130_fd_sc_hd__a22o_1 abstract view
.subckt sky130_fd_sc_hd__a22o_1 A1 A2 B1 B2 VGND VNB VPB VPWR X
.ends

* Black-box entry subcircuit for tg_mux4_x1 abstract view
.subckt tg_mux4_x1 A0 A1 A2 A3 S0 S1 VGND VNB VPB VPWR X
.ends

* Black-box entry subcircuit for sky130_fd_sc_hd__o21a_1 abstract view
.subckt sky130_fd_sc_hd__o21a_1 A1 A2 B1 VGND VNB VPB VPWR X
.ends

* Black-box entry subcircuit for sky130_fd_sc_hd__a211oi_1 abstract view
.subckt sky130_fd_sc_hd__a211oi_1 A1 A2 B1 C1 VGND VNB VPB VPWR Y
.ends

* Black-box entry subcircuit for sky130_fd_sc_hd__buf_8 abstract view
.subckt sky130_fd_sc_hd__buf_8 A VGND VNB VPB VPWR X
.ends

* Black-box entry subcircuit for sky130_fd_sc_hd__buf_12 abstract view
.subckt sky130_fd_sc_hd__buf_12 A VGND VNB VPB VPWR X
.ends

* Black-box entry subcircuit for sky130_fd_sc_hd__buf_6 abstract view
.subckt sky130_fd_sc_hd__buf_6 A VGND VNB VPB VPWR X
.ends

* Black-box entry subcircuit for sky130_fd_sc_hd__or4_1 abstract view
.subckt sky130_fd_sc_hd__or4_1 A B C D VGND VNB VPB VPWR X
.ends

* Black-box entry subcircuit for sky130_fd_sc_hd__buf_2 abstract view
.subckt sky130_fd_sc_hd__buf_2 A VGND VNB VPB VPWR X
.ends

* Black-box entry subcircuit for sky130_fd_sc_hd__a22oi_1 abstract view
.subckt sky130_fd_sc_hd__a22oi_1 A1 A2 B1 B2 VGND VNB VPB VPWR Y
.ends

* Black-box entry subcircuit for sky130_fd_sc_hd__xnor2_1 abstract view
.subckt sky130_fd_sc_hd__xnor2_1 A B VGND VNB VPB VPWR Y
.ends

* Black-box entry subcircuit for sky130_fd_sc_hd__dfrtp_1 abstract view
.subckt sky130_fd_sc_hd__dfrtp_1 CLK D RESET_B VGND VNB VPB VPWR Q
.ends

* Black-box entry subcircuit for sky130_fd_sc_hd__a41o_1 abstract view
.subckt sky130_fd_sc_hd__a41o_1 A1 A2 A3 A4 B1 VGND VNB VPB VPWR X
.ends

* Black-box entry subcircuit for sky130_fd_sc_hd__o22a_1 abstract view
.subckt sky130_fd_sc_hd__o22a_1 A1 A2 B1 B2 VGND VNB VPB VPWR X
.ends

* Black-box entry subcircuit for sky130_fd_sc_hd__o31ai_1 abstract view
.subckt sky130_fd_sc_hd__o31ai_1 A1 A2 A3 B1 VGND VNB VPB VPWR Y
.ends

* Black-box entry subcircuit for sky130_fd_sc_hd__and2_1 abstract view
.subckt sky130_fd_sc_hd__and2_1 A B VGND VNB VPB VPWR X
.ends

* Black-box entry subcircuit for sky130_fd_sc_hd__o2bb2ai_1 abstract view
.subckt sky130_fd_sc_hd__o2bb2ai_1 A1_N A2_N B1 B2 VGND VNB VPB VPWR Y
.ends

* Black-box entry subcircuit for sky130_fd_sc_hd__inv_12 abstract view
.subckt sky130_fd_sc_hd__inv_12 A VGND VNB VPB VPWR Y
.ends

* Black-box entry subcircuit for sky130_fd_sc_hd__a221oi_1 abstract view
.subckt sky130_fd_sc_hd__a221oi_1 A1 A2 B1 B2 C1 VGND VNB VPB VPWR Y
.ends

* Black-box entry subcircuit for sky130_fd_sc_hd__nand4b_1 abstract view
.subckt sky130_fd_sc_hd__nand4b_1 A_N B C D VGND VNB VPB VPWR Y
.ends

* Black-box entry subcircuit for sky130_fd_sc_hd__inv_1 abstract view
.subckt sky130_fd_sc_hd__inv_1 A VGND VNB VPB VPWR Y
.ends

* Black-box entry subcircuit for sky130_fd_sc_hd__a21boi_1 abstract view
.subckt sky130_fd_sc_hd__a21boi_1 A1 A2 B1_N VGND VNB VPB VPWR Y
.ends

* Black-box entry subcircuit for sky130_fd_sc_hd__o32ai_1 abstract view
.subckt sky130_fd_sc_hd__o32ai_1 A1 A2 A3 B1 B2 VGND VNB VPB VPWR Y
.ends

* Black-box entry subcircuit for sky130_fd_sc_hd__a21o_1 abstract view
.subckt sky130_fd_sc_hd__a21o_1 A1 A2 B1 VGND VNB VPB VPWR X
.ends

* Black-box entry subcircuit for sky130_fd_sc_hd__dfstp_2 abstract view
.subckt sky130_fd_sc_hd__dfstp_2 CLK D SET_B VGND VNB VPB VPWR Q
.ends

* Black-box entry subcircuit for sky130_fd_sc_hd__inv_8 abstract view
.subckt sky130_fd_sc_hd__inv_8 A VGND VNB VPB VPWR Y
.ends

* Black-box entry subcircuit for sky130_fd_sc_hd__o211a_1 abstract view
.subckt sky130_fd_sc_hd__o211a_1 A1 A2 B1 C1 VGND VNB VPB VPWR X
.ends

* Black-box entry subcircuit for sky130_fd_sc_hd__a2111o_1 abstract view
.subckt sky130_fd_sc_hd__a2111o_1 A1 A2 B1 C1 D1 VGND VNB VPB VPWR X
.ends

* Black-box entry subcircuit for sky130_fd_sc_hd__clkinv_1 abstract view
.subckt sky130_fd_sc_hd__clkinv_1 A VGND VNB VPB VPWR Y
.ends

* Black-box entry subcircuit for sky130_fd_sc_hd__bufinv_16 abstract view
.subckt sky130_fd_sc_hd__bufinv_16 A VGND VNB VPB VPWR Y
.ends

* Black-box entry subcircuit for sky130_fd_sc_hd__or3_1 abstract view
.subckt sky130_fd_sc_hd__or3_1 A B C VGND VNB VPB VPWR X
.ends

* Black-box entry subcircuit for sky130_fd_sc_hd__a31o_1 abstract view
.subckt sky130_fd_sc_hd__a31o_1 A1 A2 A3 B1 VGND VNB VPB VPWR X
.ends

* Black-box entry subcircuit for sky130_fd_sc_hd__inv_6 abstract view
.subckt sky130_fd_sc_hd__inv_6 A VGND VNB VPB VPWR Y
.ends

* Black-box entry subcircuit for sky130_fd_sc_hd__buf_1 abstract view
.subckt sky130_fd_sc_hd__buf_1 A VGND VNB VPB VPWR X
.ends

* Black-box entry subcircuit for island abstract view
.subckt island VGND VPWR axi_from[0] axi_from[1] axi_to[0] axi_to[1] cfg_d[0] cfg_d[1]
+ cfg_d[2] cfg_d[3] cfg_idx[0] cfg_idx[1] cfg_idx[2] cfg_idx[3] cfg_idx[4] cfg_idx[5]
+ cfg_we clk pad_in[0] pad_in[1] pad_io_in[0] pad_io_in[1] pad_io_oe[0] pad_io_oe[1]
+ pad_io_out[0] pad_io_out[1] pad_out[0] pad_out[1] rst_n
.ends

* Black-box entry subcircuit for sky130_fd_sc_hd__nand3b_1 abstract view
.subckt sky130_fd_sc_hd__nand3b_1 A_N B C VGND VNB VPB VPWR Y
.ends

* Black-box entry subcircuit for sky130_fd_sc_hd__a222oi_1 abstract view
.subckt sky130_fd_sc_hd__a222oi_1 A1 A2 B1 B2 C1 C2 VGND VNB VPB VPWR Y
.ends

* Black-box entry subcircuit for sky130_fd_sc_hd__xor2_1 abstract view
.subckt sky130_fd_sc_hd__xor2_1 A B VGND VNB VPB VPWR X
.ends

* Black-box entry subcircuit for sky130_fd_sc_hd__clkinv_8 abstract view
.subckt sky130_fd_sc_hd__clkinv_8 A VGND VNB VPB VPWR Y
.ends

* Black-box entry subcircuit for sky130_fd_sc_hd__nand4bb_1 abstract view
.subckt sky130_fd_sc_hd__nand4bb_1 A_N B_N C D VGND VNB VPB VPWR Y
.ends

* Black-box entry subcircuit for sky130_fd_sc_hd__and4_1 abstract view
.subckt sky130_fd_sc_hd__and4_1 A B C D VGND VNB VPB VPWR X
.ends

* Black-box entry subcircuit for sky130_fd_sc_hd__inv_4 abstract view
.subckt sky130_fd_sc_hd__inv_4 A VGND VNB VPB VPWR Y
.ends

* Black-box entry subcircuit for sky130_fd_sc_hd__nor4bb_1 abstract view
.subckt sky130_fd_sc_hd__nor4bb_1 A B C_N D_N VGND VNB VPB VPWR Y
.ends

* Black-box entry subcircuit for sky130_fd_sc_hd__dlxtp_1 abstract view
.subckt sky130_fd_sc_hd__dlxtp_1 D GATE VGND VNB VPB VPWR Q
.ends

* Black-box entry subcircuit for sky130_fd_sc_hd__clkinvlp_4 abstract view
.subckt sky130_fd_sc_hd__clkinvlp_4 A VGND VNB VPB VPWR Y
.ends

* Black-box entry subcircuit for sky130_fd_sc_hd__nor4b_1 abstract view
.subckt sky130_fd_sc_hd__nor4b_1 A B C D_N VGND VNB VPB VPWR Y
.ends

* Black-box entry subcircuit for sky130_fd_sc_hd__o221ai_1 abstract view
.subckt sky130_fd_sc_hd__o221ai_1 A1 A2 B1 B2 C1 VGND VNB VPB VPWR Y
.ends

* Black-box entry subcircuit for sky130_fd_sc_hd__o32a_1 abstract view
.subckt sky130_fd_sc_hd__o32a_1 A1 A2 A3 B1 B2 VGND VNB VPB VPWR X
.ends

* Black-box entry subcircuit for sky130_fd_sc_hd__clkbuf_4 abstract view
.subckt sky130_fd_sc_hd__clkbuf_4 A VGND VNB VPB VPWR X
.ends

* Black-box entry subcircuit for sky130_fd_sc_hd__a311oi_1 abstract view
.subckt sky130_fd_sc_hd__a311oi_1 A1 A2 A3 B1 C1 VGND VNB VPB VPWR Y
.ends

* Black-box entry subcircuit for sky130_fd_sc_hd__conb_1 abstract view
.subckt sky130_fd_sc_hd__conb_1 VGND VNB VPB VPWR HI LO
.ends

* Black-box entry subcircuit for sky130_fd_sc_hd__o311a_1 abstract view
.subckt sky130_fd_sc_hd__o311a_1 A1 A2 A3 B1 C1 VGND VNB VPB VPWR X
.ends

* Black-box entry subcircuit for sky130_fd_sc_hd__a32o_1 abstract view
.subckt sky130_fd_sc_hd__a32o_1 A1 A2 A3 B1 B2 VGND VNB VPB VPWR X
.ends

* Black-box entry subcircuit for top abstract view
.subckt top vdd vss clk dbg_busy dbg_outp dbg_start eoc irq rst_n s_axi_araddr s_axi_arready
+ s_axi_arvalid s_axi_awaddr s_axi_awready s_axi_awvalid s_axi_bready s_axi_bresp[0]
+ s_axi_bresp[1] s_axi_bvalid s_axi_rdata[0] s_axi_rdata[1] s_axi_rdata[2] s_axi_rdata[3]
+ s_axi_rdata[4] s_axi_rdata[5] s_axi_rdata[6] s_axi_rdata[7] s_axi_rready s_axi_rresp[0]
+ s_axi_rresp[1] s_axi_rvalid s_axi_wdata s_axi_wready s_axi_wstrb s_axi_wvalid sdo
+ sdo_valid start vin
.ends

* Black-box entry subcircuit for sky130_fd_sc_hd__and3b_1 abstract view
.subckt sky130_fd_sc_hd__and3b_1 A_N B C VGND VNB VPB VPWR X
.ends

* Black-box entry subcircuit for sky130_fd_sc_hd__o41ai_1 abstract view
.subckt sky130_fd_sc_hd__o41ai_1 A1 A2 A3 A4 B1 VGND VNB VPB VPWR Y
.ends

* Black-box entry subcircuit for sky130_fd_sc_hd__a41oi_1 abstract view
.subckt sky130_fd_sc_hd__a41oi_1 A1 A2 A3 A4 B1 VGND VNB VPB VPWR Y
.ends

* Black-box entry subcircuit for sky130_fd_sc_hd__or3b_1 abstract view
.subckt sky130_fd_sc_hd__or3b_1 A B C_N VGND VNB VPB VPWR X
.ends

* Black-box entry subcircuit for sky130_fd_sc_hd__o2111ai_1 abstract view
.subckt sky130_fd_sc_hd__o2111ai_1 A1 A2 B1 C1 D1 VGND VNB VPB VPWR Y
.ends

* Black-box entry subcircuit for sky130_fd_sc_hd__and4b_1 abstract view
.subckt sky130_fd_sc_hd__and4b_1 A_N B C D VGND VNB VPB VPWR X
.ends

* Black-box entry subcircuit for sky130_fd_sc_hd__o31a_1 abstract view
.subckt sky130_fd_sc_hd__o31a_1 A1 A2 A3 B1 VGND VNB VPB VPWR X
.ends

* Black-box entry subcircuit for sky130_fd_sc_hd__a21oi_2 abstract view
.subckt sky130_fd_sc_hd__a21oi_2 A1 A2 B1 VGND VNB VPB VPWR Y
.ends

.subckt tt_um_wereng_analog_2x2 VDPWR VGND clk ena rst_n ua[0] ua[1] ua[2] ua[3] ua[4]
+ ua[5] ua[6] ua[7] ui_in[0] ui_in[1] ui_in[2] ui_in[3] ui_in[4] ui_in[5] ui_in[6]
+ ui_in[7] uio_in[0] uio_in[1] uio_in[2] uio_in[3] uio_in[4] uio_in[5] uio_in[6] uio_in[7]
+ uio_oe[0] uio_oe[1] uio_oe[2] uio_oe[3] uio_oe[4] uio_oe[5] uio_oe[6] uio_oe[7]
+ uio_out[0] uio_out[1] uio_out[2] uio_out[3] uio_out[4] uio_out[5] uio_out[6] uio_out[7]
+ uo_out[0] uo_out[1] uo_out[2] uo_out[3] uo_out[4] uo_out[5] uo_out[6] uo_out[7]
XFILLER_39_233 VGND VGND VDPWR VDPWR sky130_fd_sc_hd__decap_3
XFILLER_54_225 VGND VGND VDPWR VDPWR sky130_fd_sc_hd__decap_3
X_2106_ _2106_/A _2106_/B hold24/A VGND VGND VDPWR VDPWR _2219_/D sky130_fd_sc_hd__nor3b_1
X_2037_ _2048_/C _2035_/Y _1986_/Y VGND VGND VDPWR VDPWR _2037_/Y sky130_fd_sc_hd__a21oi_1
XFILLER_22_188 VGND VGND VDPWR VDPWR sky130_fd_sc_hd__decap_3
Xu_sub.u_core.u_regfile.g_word\[4\].g_byte\[3\].u_lat wire103/A wire102/X max_cap99/X
+ wire97/A wire95/A max_cap94/X wire92/X max_cap90/X u_sub.u_core.u_regfile.g_word\[4\].g_byte\[3\].u_lat/GATE
+ VGND VDPWR u_sub.u_core.u_regfile.g_word\[4\].g_byte\[3\].u_lat/Q0 u_sub.u_core.u_regfile.g_word\[4\].g_byte\[3\].u_lat/Q1
+ u_sub.u_core.u_regfile.g_word\[4\].g_byte\[3\].u_lat/Q2 u_sub.u_core.u_regfile.g_word\[4\].g_byte\[3\].u_lat/Q3
+ u_sub.u_core.u_regfile.g_word\[4\].g_byte\[3\].u_lat/Q4 u_sub.u_core.u_regfile.g_word\[4\].g_byte\[3\].u_lat/Q5
+ u_sub.u_core.u_regfile.g_word\[4\].g_byte\[3\].u_lat/Q6 u_sub.u_core.u_regfile.g_word\[4\].g_byte\[3\].u_lat/Q7
+ dlxtp8_x1
XFILLER_13_188 VGND VGND VDPWR VDPWR sky130_fd_sc_hd__decap_3
Xclkbuf_3_6__f_clk_regs clkbuf_0_clk_regs/X VGND VGND VDPWR VDPWR clkload8/A sky130_fd_sc_hd__clkbuf_2
XFILLER_68_317 VGND VGND VDPWR VDPWR sky130_fd_sc_hd__fill_2
XFILLER_36_258 VGND VGND VDPWR VDPWR sky130_fd_sc_hd__decap_3
X_1270_ _1832_/A _1270_/B VGND VGND VDPWR VDPWR _1270_/Y sky130_fd_sc_hd__nand2_1
XFILLER_51_217 VGND VGND VDPWR VDPWR sky130_fd_sc_hd__fill_2
XFILLER_51_239 VGND VGND VDPWR VDPWR sky130_fd_sc_hd__decap_3
X_1606_ _1826_/C _1606_/B VGND VGND VDPWR VDPWR _1610_/C sky130_fd_sc_hd__nand2_1
X_1537_ _1538_/B _1814_/A VGND VGND VDPWR VDPWR _1537_/Y sky130_fd_sc_hd__nand2_1
X_1468_ _1691_/A _2117_/A VGND VGND VDPWR VDPWR _1740_/C sky130_fd_sc_hd__nor2_1
X_1399_ _1399_/A _1399_/B _1399_/C VGND VGND VDPWR VDPWR _1479_/B sky130_fd_sc_hd__nand3_1
XFILLER_27_225 VGND VGND VDPWR VDPWR sky130_fd_sc_hd__decap_3
Xu_sub.u_timer.g_cmp\[1\].u_cg.u_icg delaybuf_2_clk/A _1612_/Y VGND VGND VDPWR VDPWR
+ clkbuf_0_u_sub.u_timer.g_cmp\[1\].g/A sky130_fd_sc_hd__dlclkp_1
XFILLER_37_51 VGND VGND VDPWR VDPWR sky130_fd_sc_hd__fill_2
XFILLER_33_239 VGND VGND VDPWR VDPWR sky130_fd_sc_hd__fill_1
XFILLER_41_261 VGND VGND VDPWR VDPWR sky130_fd_sc_hd__fill_2
X_1322_ _2245_/Q _1322_/B VGND VGND VDPWR VDPWR _1324_/A sky130_fd_sc_hd__nand2_1
X_1253_ _1255_/B _1255_/C VGND VGND VDPWR VDPWR _1256_/B sky130_fd_sc_hd__or2_1
X_1184_ _1367_/B _1063_/A VGND VGND VDPWR VDPWR _1401_/B sky130_fd_sc_hd__nor2b_1
XPHY_EDGE_ROW_49_Left_108 VGND VDPWR sky130_fd_sc_hd__tapvpwrvgnd_1
XFILLER_59_103 VGND VGND VDPWR VDPWR sky130_fd_sc_hd__fill_1
XPHY_EDGE_ROW_58_Left_117 VGND VDPWR sky130_fd_sc_hd__tapvpwrvgnd_1
XFILLER_67_180 VGND VGND VDPWR VDPWR sky130_fd_sc_hd__decap_3
XFILLER_67_191 VGND VGND VDPWR VDPWR sky130_fd_sc_hd__fill_2
XFILLER_15_228 VGND VGND VDPWR VDPWR sky130_fd_sc_hd__decap_3
XPHY_EDGE_ROW_67_Left_126 VGND VDPWR sky130_fd_sc_hd__tapvpwrvgnd_1
XTAP_TAPCELL_ROW_72_318 VGND VDPWR sky130_fd_sc_hd__tapvpwrvgnd_1
XTAP_TAPCELL_ROW_80_362 VGND VDPWR sky130_fd_sc_hd__tapvpwrvgnd_1
XPHY_EDGE_ROW_76_Left_135 VGND VDPWR sky130_fd_sc_hd__tapvpwrvgnd_1
XFILLER_65_128 VGND VGND VDPWR VDPWR sky130_fd_sc_hd__decap_3
Xmax_cap5 _2060_/Y VGND VGND VDPWR VDPWR _2088_/A sky130_fd_sc_hd__buf_4
X_1940_ _2183_/Q wire2/X _1803_/A VGND VGND VDPWR VDPWR _1940_/Y sky130_fd_sc_hd__o21ai_1
X_1871_ _1871_/A _1871_/B VGND VGND VDPWR VDPWR _1871_/Y sky130_fd_sc_hd__nor2_1
XFILLER_49_180 VGND VGND VDPWR VDPWR sky130_fd_sc_hd__decap_3
X_2285_ _2289_/CLK hold29/X VGND VGND VDPWR VDPWR hold35/A sky130_fd_sc_hd__dfxtp_1
X_1305_ _1259_/B _1290_/Y _1302_/Y _1304_/Y VGND VGND VDPWR VDPWR _1305_/Y sky130_fd_sc_hd__o211ai_1
X_1236_ _1236_/A _1236_/B _1247_/C VGND VGND VDPWR VDPWR _1241_/B sky130_fd_sc_hd__and3_1
X_1098_ _1236_/B _1097_/B _1124_/C VGND VGND VDPWR VDPWR _1635_/B sky130_fd_sc_hd__o21ai_1
Xclkbuf_0_u_sub.u_core.pc_gclk u_sub.u_core.u_cg_pc.u_icg/GCLK VGND VGND VDPWR VDPWR
+ clkbuf_0_u_sub.u_core.pc_gclk/X sky130_fd_sc_hd__clkbuf_2
Xu_sub.u_core.u_regfile.g_nibsel\[3\].g_nib\[0\].u_m2 u_sub.u_core.u_regfile.g_nibsel\[3\].g_nib\[0\].u_lo/X
+ u_sub.u_core.u_regfile.g_nibsel\[3\].g_nib\[0\].u_hi/X wire76/X VGND VGND VDPWR
+ VDPWR u_sub.u_core.u_regfile.g_port\[0\].u_b/A2 sky130_fd_sc_hd__mux2_1
X_1167_ _1168_/B _1643_/A _1167_/C VGND VGND VDPWR VDPWR _1167_/Y sky130_fd_sc_hd__nor3_1
XFILLER_69_16 VGND VGND VDPWR VDPWR sky130_fd_sc_hd__decap_3
XFILLER_69_38 VGND VGND VDPWR VDPWR sky130_fd_sc_hd__decap_3
XFILLER_47_106 VGND VGND VDPWR VDPWR sky130_fd_sc_hd__decap_3
XFILLER_70_131 VGND VGND VDPWR VDPWR sky130_fd_sc_hd__decap_3
Xwire100 _2174_/Q VGND VGND VDPWR VDPWR wire100/X sky130_fd_sc_hd__clkbuf_8
X_2070_ _2211_/Q _2210_/Q _2209_/Q _2208_/Q VGND VGND VDPWR VDPWR _2076_/B sky130_fd_sc_hd__nand4_1
XFILLER_61_186 VGND VGND VDPWR VDPWR sky130_fd_sc_hd__fill_2
X_1923_ _2230_/Q _1923_/B VGND VGND VDPWR VDPWR _1923_/Y sky130_fd_sc_hd__nand2_1
X_1854_ _2170_/Q _1854_/B VGND VGND VDPWR VDPWR _1854_/Y sky130_fd_sc_hd__nand2b_1
X_1785_ _2144_/Q _1789_/B VGND VGND VDPWR VDPWR _1785_/Y sky130_fd_sc_hd__nand2_1
XFILLER_69_220 VGND VGND VDPWR VDPWR sky130_fd_sc_hd__fill_2
X_2268_ _2273_/CLK hold39/X VGND VGND VDPWR VDPWR hold43/A sky130_fd_sc_hd__dfxtp_1
X_2199_ clkload9/A _2199_/D VGND VGND VDPWR VDPWR uio_out[1] sky130_fd_sc_hd__dfxtp_1
X_1219_ _1063_/A _1221_/B _1377_/B1 _1578_/A VGND VGND VDPWR VDPWR _1220_/D sky130_fd_sc_hd__a211o_1
XFILLER_52_131 VGND VGND VDPWR VDPWR sky130_fd_sc_hd__decap_3
XFILLER_52_153 VGND VGND VDPWR VDPWR sky130_fd_sc_hd__fill_2
XFILLER_71_28 VGND VGND VDPWR VDPWR sky130_fd_sc_hd__decap_3
Xhold30 hold30/A VGND VGND VDPWR VDPWR hold30/X sky130_fd_sc_hd__dlygate4sd3_1
Xhold41 hold41/A VGND VGND VDPWR VDPWR hold41/X sky130_fd_sc_hd__dlygate4sd3_1
Xhold52 hold52/A VGND VGND VDPWR VDPWR hold52/X sky130_fd_sc_hd__dlygate4sd3_1
Xhold63 hold63/A VGND VGND VDPWR VDPWR hold63/X sky130_fd_sc_hd__dlygate4sd3_1
XFILLER_35_109 VGND VGND VDPWR VDPWR sky130_fd_sc_hd__decap_3
XFILLER_43_131 VGND VGND VDPWR VDPWR sky130_fd_sc_hd__decap_3
XFILLER_43_153 VGND VGND VDPWR VDPWR sky130_fd_sc_hd__decap_3
XFILLER_61_50 VGND VGND VDPWR VDPWR sky130_fd_sc_hd__decap_3
XANTENNA_5 uio_in[7] VGND VGND VDPWR VDPWR sky130_fd_sc_hd__diode_2
X_1570_ _1570_/A _1592_/B VGND VGND VDPWR VDPWR _1605_/B sky130_fd_sc_hd__nand2_1
X_2122_ _2315_/A _2122_/B VGND VGND VDPWR VDPWR _2123_/C sky130_fd_sc_hd__nand2_1
X_2053_ _2206_/Q _2053_/B VGND VGND VDPWR VDPWR _2054_/B sky130_fd_sc_hd__nor2_1
XFILLER_19_194 VGND VGND VDPWR VDPWR sky130_fd_sc_hd__decap_3
XTAP_TAPCELL_ROW_44_181 VGND VDPWR sky130_fd_sc_hd__tapvpwrvgnd_1
X_1906_ _1885_/A _1903_/Y _1904_/Y _1905_/Y VGND VGND VDPWR VDPWR _1907_/C sky130_fd_sc_hd__a31oi_1
X_1837_ _2160_/Q _1835_/Y wire86/X VGND VGND VDPWR VDPWR _2160_/D sky130_fd_sc_hd__mux2_1
X_1768_ _2150_/Q _2149_/Q _1765_/Y _1789_/B _2138_/Q VGND VGND VDPWR VDPWR _1769_/A
+ sky130_fd_sc_hd__a32oi_1
XFILLER_57_201 VGND VGND VDPWR VDPWR sky130_fd_sc_hd__fill_2
Xdelaybuf_10_clk delaybuf_9_clk/X VGND VGND VDPWR VDPWR delaybuf_11_clk/A sky130_fd_sc_hd__clkbuf_2
X_1699_ _2014_/A _1748_/A VGND VGND VDPWR VDPWR _1938_/B sky130_fd_sc_hd__nor2b_1
XTAP_TAPCELL_ROW_67_295 VGND VDPWR sky130_fd_sc_hd__tapvpwrvgnd_1
XFILLER_40_112 VGND VGND VDPWR VDPWR sky130_fd_sc_hd__fill_1
XFILLER_40_123 VGND VGND VDPWR VDPWR sky130_fd_sc_hd__fill_2
Xclkbuf_3_5__f_clk_regs clkbuf_0_clk_regs/X VGND VGND VDPWR VDPWR _2291_/CLK sky130_fd_sc_hd__clkbuf_2
XFILLER_56_50 VGND VGND VDPWR VDPWR sky130_fd_sc_hd__decap_3
XTAP_TAPCELL_ROW_58_251 VGND VDPWR sky130_fd_sc_hd__tapvpwrvgnd_1
X_1622_ _1829_/A _1680_/A VGND VGND VDPWR VDPWR _1633_/B sky130_fd_sc_hd__nand2_1
X_1553_ _1553_/A _1553_/B VGND VGND VDPWR VDPWR _2235_/D sky130_fd_sc_hd__nand2_1
X_1484_ _2207_/Q _1484_/B VGND VGND VDPWR VDPWR _1484_/Y sky130_fd_sc_hd__nor2_1
X_2105_ _2217_/Q _2218_/Q _2219_/Q VGND VGND VDPWR VDPWR _2106_/B sky130_fd_sc_hd__a21oi_1
X_2036_ _2036_/A _2036_/B VGND VGND VDPWR VDPWR _2036_/Y sky130_fd_sc_hd__nor2_1
XFILLER_60_218 VGND VGND VDPWR VDPWR sky130_fd_sc_hd__fill_2
XTAP_TAPCELL_ROW_55_232 VGND VDPWR sky130_fd_sc_hd__tapvpwrvgnd_1
XFILLER_42_85 VGND VGND VDPWR VDPWR sky130_fd_sc_hd__decap_3
XFILLER_42_96 VGND VGND VDPWR VDPWR sky130_fd_sc_hd__decap_3
XFILLER_36_237 VGND VGND VDPWR VDPWR sky130_fd_sc_hd__fill_2
X_1605_ _1605_/A _1605_/B _1610_/A _1610_/B VGND VGND VDPWR VDPWR _1605_/Y sky130_fd_sc_hd__nor4_1
X_1536_ _2229_/Q _1517_/A _1535_/Y VGND VGND VDPWR VDPWR _1814_/A sky130_fd_sc_hd__a21oi_1
XTAP_TAPCELL_ROW_69_302 VGND VDPWR sky130_fd_sc_hd__tapvpwrvgnd_1
X_1467_ _1393_/B _1464_/B _1728_/B VGND VGND VDPWR VDPWR _1467_/Y sky130_fd_sc_hd__o21ai_1
X_1398_ _1727_/B _1396_/Y _1397_/Y _1321_/Y VGND VGND VDPWR VDPWR _2258_/D sky130_fd_sc_hd__o22ai_1
X_2019_ uio_out[1] _2041_/A _2004_/Y _2018_/Y VGND VGND VDPWR VDPWR _2199_/D sky130_fd_sc_hd__a22o_1
XFILLER_50_273 VGND VGND VDPWR VDPWR sky130_fd_sc_hd__fill_2
Xu_sub.u_core.u_regfile.g_nibsel\[3\].g_nib\[2\].u_hi u_sub.u_core.u_regfile.g_word\[3\].g_byte\[2\].u_lat/Q2
+ u_sub.u_core.u_regfile.g_word\[3\].g_byte\[2\].u_lat/Q6 u_sub.u_core.u_regfile.g_word\[3\].g_byte\[3\].u_lat/Q2
+ u_sub.u_core.u_regfile.g_word\[3\].g_byte\[3\].u_lat/Q6 max_cap80/X max_cap4/X VGND
+ VGND VDPWR VDPWR u_sub.u_core.u_regfile.g_nibsel\[3\].g_nib\[2\].u_hi/X tg_mux4_x1
XFILLER_18_226 VGND VGND VDPWR VDPWR sky130_fd_sc_hd__decap_3
XFILLER_53_51 VGND VGND VDPWR VDPWR sky130_fd_sc_hd__decap_3
XTAP_TAPCELL_ROW_12_2_2_141 VGND VDPWR sky130_fd_sc_hd__tapvpwrvgnd_1
X_1321_ _1727_/B _1887_/B VGND VGND VDPWR VDPWR _1321_/Y sky130_fd_sc_hd__nand2_1
X_1252_ _1251_/A _1251_/B _1307_/A VGND VGND VDPWR VDPWR _1255_/C sky130_fd_sc_hd__o21a_1
X_1183_ _1200_/B _1182_/Y _1181_/X _1155_/Y VGND VGND VDPWR VDPWR _1199_/B sky130_fd_sc_hd__a211oi_1
X_1519_ _1519_/A _1558_/B _1519_/C VGND VGND VDPWR VDPWR _1522_/B sky130_fd_sc_hd__nand3_1
XFILLER_55_343 VGND VGND VDPWR VDPWR sky130_fd_sc_hd__fill_2
XPHY_EDGE_ROW_25_2_2_Right_44 VGND VDPWR sky130_fd_sc_hd__tapvpwrvgnd_1
XTAP_TAPCELL_ROW_72_319 VGND VDPWR sky130_fd_sc_hd__tapvpwrvgnd_1
XTAP_TAPCELL_ROW_80_363 VGND VDPWR sky130_fd_sc_hd__tapvpwrvgnd_1
XFILLER_2_188 VGND VGND VDPWR VDPWR sky130_fd_sc_hd__fill_1
XFILLER_64_72 VGND VGND VDPWR VDPWR sky130_fd_sc_hd__decap_3
Xmax_cap6 max_cap7/X VGND VGND VDPWR VDPWR max_cap6/X sky130_fd_sc_hd__buf_8
X_1870_ _1870_/A _1870_/B _1870_/C _1870_/D VGND VGND VDPWR VDPWR _1871_/B sky130_fd_sc_hd__nor4_1
XFILLER_37_310 VGND VGND VDPWR VDPWR sky130_fd_sc_hd__decap_3
XFILLER_56_118 VGND VGND VDPWR VDPWR sky130_fd_sc_hd__decap_3
X_2284_ _2289_/CLK hold28/X VGND VGND VDPWR VDPWR hold32/A sky130_fd_sc_hd__dfxtp_1
X_1304_ _1638_/A _1304_/B VGND VGND VDPWR VDPWR _1304_/Y sky130_fd_sc_hd__nand2b_1
X_1235_ _1233_/Y _1234_/Y _1615_/B VGND VGND VDPWR VDPWR _1241_/A sky130_fd_sc_hd__a21oi_1
X_1166_ _1871_/A _1191_/A _1248_/B VGND VGND VDPWR VDPWR _1167_/C sky130_fd_sc_hd__o21ai_1
XFILLER_20_210 VGND VGND VDPWR VDPWR sky130_fd_sc_hd__fill_1
XFILLER_64_173 VGND VGND VDPWR VDPWR sky130_fd_sc_hd__fill_1
X_1097_ _1124_/C _1097_/B VGND VGND VDPWR VDPWR _1376_/C sky130_fd_sc_hd__nand2_1
Xclkbuf_1_0__f_u_sub.u_timer.g_cmp\[0\].g clkbuf_0_u_sub.u_timer.g_cmp\[0\].g/X VGND
+ VGND VDPWR VDPWR _2297_/GATE sky130_fd_sc_hd__clkbuf_2
X_1999_ _2203_/Q _2205_/Q _2204_/Q VGND VGND VDPWR VDPWR _1999_/X sky130_fd_sc_hd__and3_1
XFILLER_47_118 VGND VGND VDPWR VDPWR sky130_fd_sc_hd__decap_3
Xu_sub.u_core.u_cg_epc.u_icg clkload1/A _1467_/Y VGND VGND VDPWR VDPWR u_sub.u_core.u_cg_epc.u_icg/GCLK
+ sky130_fd_sc_hd__dlclkp_1
Xwire123 _2137_/Q VGND VGND VDPWR VDPWR wire123/X sky130_fd_sc_hd__buf_12
Xwire101 wire102/X VGND VGND VDPWR VDPWR wire101/X sky130_fd_sc_hd__buf_6
XFILLER_59_94 VGND VGND VDPWR VDPWR sky130_fd_sc_hd__decap_3
Xclkbuf_0_u_sub.u_core.epc_gclk u_sub.u_core.u_cg_epc.u_icg/GCLK VGND VGND VDPWR VDPWR
+ clkbuf_0_u_sub.u_core.epc_gclk/X sky130_fd_sc_hd__clkbuf_2
XFILLER_34_324 VGND VGND VDPWR VDPWR sky130_fd_sc_hd__decap_3
XFILLER_46_184 VGND VGND VDPWR VDPWR sky130_fd_sc_hd__decap_3
XFILLER_61_121 VGND VGND VDPWR VDPWR sky130_fd_sc_hd__decap_3
X_1922_ _2125_/A _2125_/B _2125_/C VGND VGND VDPWR VDPWR _2174_/D sky130_fd_sc_hd__nor3_1
X_1853_ _1853_/A _1853_/B _1853_/C _1853_/D VGND VGND VDPWR VDPWR _1854_/B sky130_fd_sc_hd__or4_1
X_1784_ _1784_/A _1784_/B VGND VGND VDPWR VDPWR _2143_/D sky130_fd_sc_hd__nor2_1
XFILLER_69_243 VGND VGND VDPWR VDPWR sky130_fd_sc_hd__fill_2
X_2267_ _2274_/CLK hold46/X VGND VGND VDPWR VDPWR hold44/A sky130_fd_sc_hd__dfxtp_1
X_2198_ _2291_/CLK _2198_/D VGND VGND VDPWR VDPWR uio_out[0] sky130_fd_sc_hd__dfxtp_1
X_1218_ _1207_/Y _1217_/Y _1211_/B _1376_/B VGND VGND VDPWR VDPWR _1220_/C sky130_fd_sc_hd__o211ai_1
X_1149_ _1137_/A _1182_/A _1236_/A _1148_/Y VGND VGND VDPWR VDPWR _1149_/Y sky130_fd_sc_hd__a31oi_1
XFILLER_52_176 VGND VGND VDPWR VDPWR sky130_fd_sc_hd__decap_3
Xclkbuf_1_1__f_u_sub.u_core.epc_gclk clkbuf_0_u_sub.u_core.epc_gclk/X VGND VGND VDPWR
+ VDPWR _2290_/CLK sky130_fd_sc_hd__clkbuf_2
Xclkbuf_3_4__f_clk_regs clkbuf_0_clk_regs/X VGND VGND VDPWR VDPWR clkload7/A sky130_fd_sc_hd__clkbuf_2
Xhold31 hold31/A VGND VGND VDPWR VDPWR hold31/X sky130_fd_sc_hd__dlygate4sd3_1
Xhold42 hold42/A VGND VGND VDPWR VDPWR hold42/X sky130_fd_sc_hd__dlygate4sd3_1
Xhold53 hold53/A VGND VGND VDPWR VDPWR hold53/X sky130_fd_sc_hd__dlygate4sd3_1
Xhold64 hold64/A VGND VGND VDPWR VDPWR hold64/X sky130_fd_sc_hd__dlygate4sd3_1
XFILLER_45_85 VGND VGND VDPWR VDPWR sky130_fd_sc_hd__fill_1
XANTENNA_6 wire70/X VGND VGND VDPWR VDPWR sky130_fd_sc_hd__diode_2
XFILLER_61_95 VGND VGND VDPWR VDPWR sky130_fd_sc_hd__fill_2
XFILLER_66_202 VGND VGND VDPWR VDPWR sky130_fd_sc_hd__fill_2
XFILLER_66_257 VGND VGND VDPWR VDPWR sky130_fd_sc_hd__fill_1
X_2121_ wire70/A _2121_/B _2121_/C VGND VGND VDPWR VDPWR _2123_/B sky130_fd_sc_hd__nand3_1
X_2052_ _2052_/A _2052_/B VGND VGND VDPWR VDPWR _2205_/D sky130_fd_sc_hd__nor2_1
X_1905_ _2163_/Q _1885_/A _1506_/B VGND VGND VDPWR VDPWR _1905_/Y sky130_fd_sc_hd__o21ai_1
X_1836_ _2157_/Q _1836_/B _1836_/C VGND VGND VDPWR VDPWR wire86/A sky130_fd_sc_hd__nor3_1
X_1767_ wire69/X _1792_/B VGND VGND VDPWR VDPWR _1789_/B sky130_fd_sc_hd__nand2_1
X_1698_ _2260_/Q _2244_/Q _2034_/S VGND VGND VDPWR VDPWR _2014_/A sky130_fd_sc_hd__mux2_1
X_2319_ _2319_/A VGND VGND VDPWR VDPWR uo_out[6] sky130_fd_sc_hd__buf_2
XFILLER_40_135 VGND VGND VDPWR VDPWR sky130_fd_sc_hd__fill_1
XTAP_TAPCELL_ROW_67_296 VGND VDPWR sky130_fd_sc_hd__tapvpwrvgnd_1
Xdelaybuf_3_clk delaybuf_3_clk/A VGND VGND VDPWR VDPWR delaybuf_4_clk/A sky130_fd_sc_hd__clkbuf_2
XFILLER_48_202 VGND VGND VDPWR VDPWR sky130_fd_sc_hd__fill_2
Xu_sub.u_core.u_cg_wb_lo.u_icg clkbuf_leaf_4_clk/X _1461_/Y VGND VGND VDPWR VDPWR
+ u_sub.u_core.u_cg_wb_lo.u_icg/GCLK sky130_fd_sc_hd__dlclkp_1
X_1621_ _1836_/B _1621_/B VGND VGND VDPWR VDPWR _1621_/Y sky130_fd_sc_hd__nor2_1
X_1552_ _1552_/A _1680_/A _1560_/A VGND VGND VDPWR VDPWR _1553_/B sky130_fd_sc_hd__nand3_1
XFILLER_39_224 VGND VGND VDPWR VDPWR sky130_fd_sc_hd__decap_3
X_2104_ hold144/X hold137/X _2103_/Y VGND VGND VDPWR VDPWR _2218_/D sky130_fd_sc_hd__a21oi_1
X_1483_ _2206_/Q _2204_/Q _2203_/Q VGND VGND VDPWR VDPWR _1484_/B sky130_fd_sc_hd__o21ai_1
XFILLER_62_271 VGND VGND VDPWR VDPWR sky130_fd_sc_hd__fill_1
XTAP_TAPCELL_ROW_64_277 VGND VDPWR sky130_fd_sc_hd__tapvpwrvgnd_1
X_2035_ _2203_/Q _1413_/X _2044_/B _2034_/X VGND VGND VDPWR VDPWR _2035_/Y sky130_fd_sc_hd__a22oi_1
XPHY_EDGE_ROW_46_Right_65 VGND VDPWR sky130_fd_sc_hd__tapvpwrvgnd_1
X_1819_ _2156_/Q _1826_/B VGND VGND VDPWR VDPWR _1836_/C sky130_fd_sc_hd__nand2_1
XPHY_EDGE_ROW_55_Right_74 VGND VDPWR sky130_fd_sc_hd__tapvpwrvgnd_1
XTAP_TAPCELL_ROW_55_233 VGND VDPWR sky130_fd_sc_hd__tapvpwrvgnd_1
XFILLER_42_75 VGND VGND VDPWR VDPWR sky130_fd_sc_hd__decap_3
XPHY_EDGE_ROW_64_Right_83 VGND VDPWR sky130_fd_sc_hd__tapvpwrvgnd_1
XFILLER_67_61 VGND VGND VDPWR VDPWR sky130_fd_sc_hd__decap_3
XPHY_EDGE_ROW_73_Right_92 VGND VDPWR sky130_fd_sc_hd__tapvpwrvgnd_1
XTAP_TAPCELL_ROW_78_347 VGND VDPWR sky130_fd_sc_hd__tapvpwrvgnd_1
XFILLER_36_205 VGND VGND VDPWR VDPWR sky130_fd_sc_hd__fill_2
Xu_sub.u_core.u_regfile.g_nibsel\[4\].g_nib\[0\].u_hi u_sub.u_core.u_regfile.g_word\[4\].g_byte\[2\].u_lat/Q0
+ u_sub.u_core.u_regfile.g_word\[4\].g_byte\[2\].u_lat/Q4 u_sub.u_core.u_regfile.g_word\[4\].g_byte\[3\].u_lat/Q0
+ u_sub.u_core.u_regfile.g_word\[4\].g_byte\[3\].u_lat/Q4 max_cap6/X max_cap79/X VGND
+ VGND VDPWR VDPWR u_sub.u_core.u_regfile.g_nibsel\[4\].g_nib\[0\].u_hi/X tg_mux4_x1
XFILLER_59_1 VGND VGND VDPWR VDPWR sky130_fd_sc_hd__fill_1
X_1604_ _1605_/A _1605_/B _1609_/A _1610_/B VGND VGND VDPWR VDPWR _1604_/Y sky130_fd_sc_hd__nor4_1
X_1535_ _2230_/Q _2229_/Q VGND VGND VDPWR VDPWR _1535_/Y sky130_fd_sc_hd__nor2_1
XTAP_TAPCELL_ROW_69_303 VGND VDPWR sky130_fd_sc_hd__tapvpwrvgnd_1
X_1466_ _1466_/A _1466_/B VGND VGND VDPWR VDPWR _1466_/Y sky130_fd_sc_hd__nand2_1
X_1397_ _1397_/A _2195_/Q VGND VGND VDPWR VDPWR _1397_/Y sky130_fd_sc_hd__xnor2_1
X_2018_ _2018_/A _2018_/B VGND VGND VDPWR VDPWR _2018_/Y sky130_fd_sc_hd__nand2_1
XFILLER_33_208 VGND VGND VDPWR VDPWR sky130_fd_sc_hd__decap_3
XFILLER_37_86 VGND VGND VDPWR VDPWR sky130_fd_sc_hd__decap_3
XFILLER_41_274 VGND VGND VDPWR VDPWR sky130_fd_sc_hd__fill_1
Xu_sub.u_core.u_regfile.g_ir\[2\].u_cg.u_icg delaybuf_0_clk/X _1609_/Y VGND VGND VDPWR
+ VDPWR u_sub.u_core.u_regfile.g_ir\[2\].u_lat/GATE sky130_fd_sc_hd__dlclkp_1
X_1320_ _1727_/B _1320_/B VGND VGND VDPWR VDPWR _2256_/D sky130_fd_sc_hd__nor2_1
X_1251_ _1251_/A _1251_/B _1307_/A VGND VGND VDPWR VDPWR _1255_/B sky130_fd_sc_hd__nor3_1
X_1182_ _1182_/A _1541_/A VGND VGND VDPWR VDPWR _1182_/Y sky130_fd_sc_hd__nand2_1
X_1518_ _2237_/Q _2233_/Q _2232_/Q VGND VGND VDPWR VDPWR _1519_/C sky130_fd_sc_hd__nor3_1
X_1449_ _1449_/A _1615_/D VGND VGND VDPWR VDPWR _1449_/X sky130_fd_sc_hd__or2_1
XFILLER_15_219 VGND VGND VDPWR VDPWR sky130_fd_sc_hd__fill_2
XFILLER_67_171 VGND VGND VDPWR VDPWR sky130_fd_sc_hd__decap_3
XTAP_TAPCELL_ROW_80_364 VGND VDPWR sky130_fd_sc_hd__tapvpwrvgnd_1
XFILLER_48_85 VGND VGND VDPWR VDPWR sky130_fd_sc_hd__fill_2
XFILLER_58_193 VGND VGND VDPWR VDPWR sky130_fd_sc_hd__decap_3
XFILLER_65_108 VGND VGND VDPWR VDPWR sky130_fd_sc_hd__decap_3
XTAP_TAPCELL_ROW_16_2_2_143 VGND VDPWR sky130_fd_sc_hd__tapvpwrvgnd_1
XFILLER_14_230 VGND VGND VDPWR VDPWR sky130_fd_sc_hd__decap_3
Xmax_cap7 _1623_/Y VGND VGND VDPWR VDPWR max_cap7/X sky130_fd_sc_hd__buf_8
X_2283_ _2290_/CLK hold27/X VGND VGND VDPWR VDPWR hold36/A sky130_fd_sc_hd__dfxtp_1
X_1303_ _1572_/A _1291_/Y _1292_/Y _1208_/B VGND VGND VDPWR VDPWR _1304_/B sky130_fd_sc_hd__o22ai_1
XFILLER_49_171 VGND VGND VDPWR VDPWR sky130_fd_sc_hd__decap_3
XFILLER_49_193 VGND VGND VDPWR VDPWR sky130_fd_sc_hd__decap_3
X_1096_ _1214_/A _1214_/B _1214_/C VGND VGND VDPWR VDPWR _1141_/B sky130_fd_sc_hd__nor3_1
X_1234_ _1079_/A _1541_/B _1656_/B VGND VGND VDPWR VDPWR _1234_/Y sky130_fd_sc_hd__a21oi_1
X_1165_ _1871_/A _1248_/B VGND VGND VDPWR VDPWR _1247_/C sky130_fd_sc_hd__nand2_1
XFILLER_20_233 VGND VGND VDPWR VDPWR sky130_fd_sc_hd__decap_3
Xclkbuf_3_3__f_clk_regs clkbuf_0_clk_regs/X VGND VGND VDPWR VDPWR clkload6/A sky130_fd_sc_hd__clkbuf_2
X_1998_ _2203_/Q _2204_/Q VGND VGND VDPWR VDPWR _2036_/B sky130_fd_sc_hd__nand2_1
XFILLER_70_122 VGND VGND VDPWR VDPWR sky130_fd_sc_hd__fill_1
XFILLER_70_144 VGND VGND VDPWR VDPWR sky130_fd_sc_hd__fill_2
XFILLER_70_155 VGND VGND VDPWR VDPWR sky130_fd_sc_hd__decap_3
XFILLER_11_233 VGND VGND VDPWR VDPWR sky130_fd_sc_hd__decap_3
Xwire124 _2136_/Q VGND VGND VDPWR VDPWR wire124/X sky130_fd_sc_hd__buf_12
Xwire102 _2173_/Q VGND VGND VDPWR VDPWR wire102/X sky130_fd_sc_hd__clkbuf_8
XFILLER_46_152 VGND VGND VDPWR VDPWR sky130_fd_sc_hd__decap_3
XFILLER_34_336 VGND VGND VDPWR VDPWR sky130_fd_sc_hd__decap_3
XFILLER_61_155 VGND VGND VDPWR VDPWR sky130_fd_sc_hd__decap_3
X_1921_ _1921_/A _1921_/B VGND VGND VDPWR VDPWR _2125_/C sky130_fd_sc_hd__nor2_1
X_1852_ hold143/X wire67/X _1852_/S VGND VGND VDPWR VDPWR _2169_/D sky130_fd_sc_hd__mux2_1
X_1783_ _2123_/A _1783_/B VGND VGND VDPWR VDPWR _1784_/B sky130_fd_sc_hd__nand2_1
XFILLER_41_1 VGND VGND VDPWR VDPWR sky130_fd_sc_hd__fill_1
X_2266_ _2274_/CLK hold48/X VGND VGND VDPWR VDPWR hold38/A sky130_fd_sc_hd__dfxtp_1
XFILLER_40_317 VGND VGND VDPWR VDPWR sky130_fd_sc_hd__fill_1
XFILLER_52_122 VGND VGND VDPWR VDPWR sky130_fd_sc_hd__decap_3
XFILLER_71_19 VGND VGND VDPWR VDPWR sky130_fd_sc_hd__decap_3
X_1079_ _1079_/A _1191_/B VGND VGND VDPWR VDPWR _1232_/A sky130_fd_sc_hd__nand2_1
Xu_sub.u_core.u_regfile.g_word\[3\].g_byte\[0\].u_cg.u_icg clkload0/A _1598_/X VGND
+ VGND VDPWR VDPWR u_sub.u_core.u_regfile.g_word\[3\].g_byte\[0\].u_lat/GATE sky130_fd_sc_hd__dlclkp_1
X_2197_ _2291_/CLK _2197_/D VGND VGND VDPWR VDPWR _2313_/A sky130_fd_sc_hd__dfxtp_1
X_1217_ _1179_/B _1208_/B _1210_/A VGND VGND VDPWR VDPWR _1217_/Y sky130_fd_sc_hd__a21oi_1
X_1148_ _1148_/A _1643_/A VGND VGND VDPWR VDPWR _1148_/Y sky130_fd_sc_hd__nor2_1
Xu_sub.u_core.u_regfile.g_word\[1\].g_byte\[2\].u_cg.u_icg clkbuf_leaf_4_clk/X _1589_/Y
+ VGND VGND VDPWR VDPWR u_sub.u_core.u_regfile.g_word\[1\].g_byte\[2\].u_lat/GATE
+ sky130_fd_sc_hd__dlclkp_1
Xhold32 hold32/A VGND VGND VDPWR VDPWR hold32/X sky130_fd_sc_hd__dlygate4sd3_1
Xhold43 hold43/A VGND VGND VDPWR VDPWR hold43/X sky130_fd_sc_hd__dlygate4sd3_1
Xhold54 hold54/A VGND VGND VDPWR VDPWR hold54/X sky130_fd_sc_hd__dlygate4sd3_1
Xhold65 hold65/A VGND VGND VDPWR VDPWR hold65/X sky130_fd_sc_hd__dlygate4sd3_1
XFILLER_61_41 VGND VGND VDPWR VDPWR sky130_fd_sc_hd__decap_3
XFILLER_66_214 VGND VGND VDPWR VDPWR sky130_fd_sc_hd__fill_2
XFILLER_66_236 VGND VGND VDPWR VDPWR sky130_fd_sc_hd__decap_3
Xu_sub.u_core.u_regfile.g_word\[3\].g_byte\[2\].u_lat wire103/X wire101/X wire100/X
+ wire97/X wire95/X max_cap93/X max_cap91/X max_cap89/X u_sub.u_core.u_regfile.g_word\[3\].g_byte\[2\].u_lat/GATE
+ VGND VDPWR u_sub.u_core.u_regfile.g_word\[3\].g_byte\[2\].u_lat/Q0 u_sub.u_core.u_regfile.g_word\[3\].g_byte\[2\].u_lat/Q1
+ u_sub.u_core.u_regfile.g_word\[3\].g_byte\[2\].u_lat/Q2 u_sub.u_core.u_regfile.g_word\[3\].g_byte\[2\].u_lat/Q3
+ u_sub.u_core.u_regfile.g_word\[3\].g_byte\[2\].u_lat/Q4 u_sub.u_core.u_regfile.g_word\[3\].g_byte\[2\].u_lat/Q5
+ u_sub.u_core.u_regfile.g_word\[3\].g_byte\[2\].u_lat/Q6 u_sub.u_core.u_regfile.g_word\[3\].g_byte\[2\].u_lat/Q7
+ dlxtp8_x1
X_2120_ _2121_/B _2121_/C VGND VGND VDPWR VDPWR _2122_/B sky130_fd_sc_hd__nand2_1
X_2051_ _2203_/Q _2204_/Q _2053_/B _2205_/Q VGND VGND VDPWR VDPWR _2052_/B sky130_fd_sc_hd__a31oi_1
X_1904_ _1904_/A _1904_/B VGND VGND VDPWR VDPWR _1904_/Y sky130_fd_sc_hd__nand2_1
X_1835_ _1809_/Y _1832_/Y _1834_/Y VGND VGND VDPWR VDPWR _1835_/Y sky130_fd_sc_hd__o21ai_1
X_1766_ _1766_/A _1766_/B VGND VGND VDPWR VDPWR _1792_/B sky130_fd_sc_hd__nor2_1
X_1697_ _1914_/S _1697_/A2 _1696_/Y VGND VGND VDPWR VDPWR _1697_/Y sky130_fd_sc_hd__a21oi_1
X_2318_ _2318_/A VGND VGND VDPWR VDPWR uo_out[5] sky130_fd_sc_hd__buf_2
X_2249_ _2258_/CLK hold58/X _2123_/A VGND VGND VDPWR VDPWR hold56/A sky130_fd_sc_hd__dfrtp_1
XFILLER_25_188 VGND VGND VDPWR VDPWR sky130_fd_sc_hd__decap_3
XFILLER_40_103 VGND VGND VDPWR VDPWR sky130_fd_sc_hd__decap_3
XFILLER_63_206 VGND VGND VDPWR VDPWR sky130_fd_sc_hd__fill_1
XFILLER_63_239 VGND VGND VDPWR VDPWR sky130_fd_sc_hd__decap_3
XFILLER_71_261 VGND VGND VDPWR VDPWR sky130_fd_sc_hd__decap_3
X_1620_ wire85/A _1620_/B VGND VGND VDPWR VDPWR _1853_/A sky130_fd_sc_hd__xnor2_1
X_1551_ _1552_/A _1680_/A VGND VGND VDPWR VDPWR _1560_/C sky130_fd_sc_hd__nand2_1
X_1482_ _1079_/A _2205_/Q _1480_/Y VGND VGND VDPWR VDPWR _1482_/Y sky130_fd_sc_hd__o21ai_1
XFILLER_39_236 VGND VGND VDPWR VDPWR sky130_fd_sc_hd__fill_2
X_2103_ _2217_/Q _2218_/Q hold24/A VGND VGND VDPWR VDPWR _2103_/Y sky130_fd_sc_hd__o21ai_1
XFILLER_54_228 VGND VGND VDPWR VDPWR sky130_fd_sc_hd__fill_2
XFILLER_62_261 VGND VGND VDPWR VDPWR sky130_fd_sc_hd__fill_2
XTAP_TAPCELL_ROW_64_278 VGND VDPWR sky130_fd_sc_hd__tapvpwrvgnd_1
X_2034_ hold49/A hold59/A _2034_/S VGND VGND VDPWR VDPWR _2034_/X sky130_fd_sc_hd__mux2_1
XFILLER_30_191 VGND VGND VDPWR VDPWR sky130_fd_sc_hd__decap_3
X_1818_ _1573_/B _1814_/Y _1817_/Y VGND VGND VDPWR VDPWR _2155_/D sky130_fd_sc_hd__o21ai_1
X_1749_ _2138_/Q _1950_/B VGND VGND VDPWR VDPWR _1750_/C sky130_fd_sc_hd__nor2_1
XTAP_TAPCELL_ROW_55_234 VGND VDPWR sky130_fd_sc_hd__tapvpwrvgnd_1
XFILLER_36_217 VGND VGND VDPWR VDPWR sky130_fd_sc_hd__fill_1
XTAP_TAPCELL_ROW_78_348 VGND VDPWR sky130_fd_sc_hd__tapvpwrvgnd_1
XTAP_TAPCELL_ROW_69_304 VGND VDPWR sky130_fd_sc_hd__tapvpwrvgnd_1
X_1603_ _1605_/A _1605_/B _1608_/A VGND VGND VDPWR VDPWR _1603_/Y sky130_fd_sc_hd__nor3_1
X_1534_ _2230_/Q _1534_/B VGND VGND VDPWR VDPWR _1538_/B sky130_fd_sc_hd__nand2_1
X_1465_ _1848_/B _2236_/Q _1465_/C VGND VGND VDPWR VDPWR _1466_/B sky130_fd_sc_hd__nand3_1
X_2017_ _2013_/Y _2015_/Y _2016_/Y _2006_/X wire69/X VGND VGND VDPWR VDPWR _2018_/B
+ sky130_fd_sc_hd__a32oi_1
X_1396_ _1277_/Y _1394_/Y _1395_/X VGND VGND VDPWR VDPWR _1396_/Y sky130_fd_sc_hd__a21oi_1
Xhold140 _2181_/Q VGND VGND VDPWR VDPWR _1932_/A sky130_fd_sc_hd__dlygate4sd3_1
XFILLER_37_10 VGND VGND VDPWR VDPWR sky130_fd_sc_hd__fill_1
Xu_sub.u_core.u_regfile.g_nibsel\[3\].g_nib\[2\].u_lo u_sub.u_core.u_regfile.g_word\[3\].g_byte\[0\].u_lat/Q2
+ u_sub.u_core.u_regfile.g_word\[3\].g_byte\[0\].u_lat/Q6 u_sub.u_core.u_regfile.g_word\[3\].g_byte\[1\].u_lat/Q2
+ u_sub.u_core.u_regfile.g_word\[3\].g_byte\[1\].u_lat/Q6 max_cap80/X max_cap4/X VGND
+ VGND VDPWR VDPWR u_sub.u_core.u_regfile.g_nibsel\[3\].g_nib\[2\].u_lo/X tg_mux4_x1
XFILLER_41_231 VGND VGND VDPWR VDPWR sky130_fd_sc_hd__fill_1
XFILLER_41_297 VGND VGND VDPWR VDPWR sky130_fd_sc_hd__decap_3
XFILLER_24_209 VGND VGND VDPWR VDPWR sky130_fd_sc_hd__decap_3
XFILLER_49_342 VGND VGND VDPWR VDPWR sky130_fd_sc_hd__decap_3
X_1250_ _1364_/A _1832_/A _1264_/C _1273_/C VGND VGND VDPWR VDPWR _1383_/A sky130_fd_sc_hd__o211ai_1
X_1181_ _1179_/B _1399_/A _1044_/Y _1399_/B _1479_/A VGND VGND VDPWR VDPWR _1181_/X
+ sky130_fd_sc_hd__a41o_1
Xclkbuf_3_2__f_clk_regs clkbuf_0_clk_regs/X VGND VGND VDPWR VDPWR clkload5/A sky130_fd_sc_hd__clkbuf_2
XFILLER_71_1 VGND VGND VDPWR VDPWR sky130_fd_sc_hd__decap_3
Xu_sub.u_core.u_regfile.g_nibsel\[1\].g_nib\[1\].u_hi u_sub.u_core.u_regfile.g_word\[1\].g_byte\[2\].u_lat/Q1
+ u_sub.u_core.u_regfile.g_word\[1\].g_byte\[2\].u_lat/Q5 u_sub.u_core.u_regfile.g_word\[1\].g_byte\[3\].u_lat/Q1
+ u_sub.u_core.u_regfile.g_word\[1\].g_byte\[3\].u_lat/Q5 max_cap6/X max_cap3/X VGND
+ VGND VDPWR VDPWR u_sub.u_core.u_regfile.g_nibsel\[1\].g_nib\[1\].u_hi/X tg_mux4_x1
XFILLER_59_128 VGND VGND VDPWR VDPWR sky130_fd_sc_hd__fill_1
X_1517_ _1517_/A _1533_/B VGND VGND VDPWR VDPWR _1558_/B sky130_fd_sc_hd__nor2_1
X_1448_ _1615_/B _1615_/C _1615_/D VGND VGND VDPWR VDPWR _1506_/B sky130_fd_sc_hd__nor3_1
XFILLER_23_231 VGND VGND VDPWR VDPWR sky130_fd_sc_hd__decap_3
XFILLER_67_183 VGND VGND VDPWR VDPWR sky130_fd_sc_hd__decap_3
X_1379_ _1638_/A _1379_/B _1379_/C _1379_/D VGND VGND VDPWR VDPWR _1379_/Y sky130_fd_sc_hd__nor4_1
XTAP_TAPCELL_ROW_80_365 VGND VDPWR sky130_fd_sc_hd__tapvpwrvgnd_1
XFILLER_48_97 VGND VGND VDPWR VDPWR sky130_fd_sc_hd__decap_3
XFILLER_58_172 VGND VGND VDPWR VDPWR sky130_fd_sc_hd__decap_3
XPHY_EDGE_ROW_45_Left_104 VGND VDPWR sky130_fd_sc_hd__tapvpwrvgnd_1
Xmax_cap8 _1844_/B VGND VGND VDPWR VDPWR _1631_/A sky130_fd_sc_hd__buf_2
XPHY_EDGE_ROW_54_Left_113 VGND VDPWR sky130_fd_sc_hd__tapvpwrvgnd_1
XPHY_EDGE_ROW_63_Left_122 VGND VDPWR sky130_fd_sc_hd__tapvpwrvgnd_1
X_2282_ _2290_/CLK hold37/X VGND VGND VDPWR VDPWR hold26/A sky130_fd_sc_hd__dfxtp_1
X_1302_ _1296_/Y _1301_/Y _1638_/A VGND VGND VDPWR VDPWR _1302_/Y sky130_fd_sc_hd__o21ai_1
X_1233_ _1871_/A _1233_/B VGND VGND VDPWR VDPWR _1233_/Y sky130_fd_sc_hd__nand2_1
XFILLER_37_323 VGND VGND VDPWR VDPWR sky130_fd_sc_hd__fill_2
XFILLER_49_183 VGND VGND VDPWR VDPWR sky130_fd_sc_hd__decap_3
XFILLER_64_131 VGND VGND VDPWR VDPWR sky130_fd_sc_hd__fill_1
X_1095_ _1200_/A _1137_/A VGND VGND VDPWR VDPWR _1214_/C sky130_fd_sc_hd__nand2b_1
X_1164_ _1871_/A _1191_/B VGND VGND VDPWR VDPWR _1541_/B sky130_fd_sc_hd__nor2_1
XPHY_EDGE_ROW_72_Left_131 VGND VDPWR sky130_fd_sc_hd__tapvpwrvgnd_1
X_1997_ _1995_/Y _1996_/Y _1986_/Y VGND VGND VDPWR VDPWR _1997_/Y sky130_fd_sc_hd__a21oi_1
XFILLER_69_19 VGND VGND VDPWR VDPWR sky130_fd_sc_hd__fill_1
XFILLER_47_109 VGND VGND VDPWR VDPWR sky130_fd_sc_hd__fill_2
XFILLER_34_66 VGND VGND VDPWR VDPWR sky130_fd_sc_hd__fill_2
XFILLER_70_134 VGND VGND VDPWR VDPWR sky130_fd_sc_hd__fill_2
Xwire125 _2135_/Q VGND VGND VDPWR VDPWR wire125/X sky130_fd_sc_hd__buf_12
Xwire103 wire103/A VGND VGND VDPWR VDPWR wire103/X sky130_fd_sc_hd__clkbuf_8
XFILLER_59_52 VGND VGND VDPWR VDPWR sky130_fd_sc_hd__fill_1
XFILLER_61_134 VGND VGND VDPWR VDPWR sky130_fd_sc_hd__decap_3
XFILLER_61_167 VGND VGND VDPWR VDPWR sky130_fd_sc_hd__decap_3
X_1920_ uio_in[2] _1898_/B _1913_/Y wire72/X VGND VGND VDPWR VDPWR _1921_/B sky130_fd_sc_hd__o22a_1
X_1851_ _2168_/Q _2294_/D _1852_/S VGND VGND VDPWR VDPWR _2168_/D sky130_fd_sc_hd__mux2_1
X_1782_ _2143_/Q _1786_/C VGND VGND VDPWR VDPWR _1783_/B sky130_fd_sc_hd__nand2_1
XFILLER_69_234 VGND VGND VDPWR VDPWR sky130_fd_sc_hd__fill_1
X_2265_ _2273_/CLK hold40/X VGND VGND VDPWR VDPWR hold51/A sky130_fd_sc_hd__dfxtp_1
X_2196_ clkload8/A _2196_/D VGND VGND VDPWR VDPWR _2196_/Q sky130_fd_sc_hd__dfxtp_1
X_1216_ _1207_/Y _1215_/Y _2155_/Q VGND VGND VDPWR VDPWR _1220_/B sky130_fd_sc_hd__o21ai_1
XFILLER_37_186 VGND VGND VDPWR VDPWR sky130_fd_sc_hd__fill_1
XFILLER_52_134 VGND VGND VDPWR VDPWR sky130_fd_sc_hd__fill_2
XTAP_TAPCELL_ROW_47_192 VGND VDPWR sky130_fd_sc_hd__tapvpwrvgnd_1
X_1078_ _1082_/A _1082_/B VGND VGND VDPWR VDPWR _1172_/B sky130_fd_sc_hd__nand2_1
X_1147_ _1147_/A _1221_/A _1162_/A _1147_/D VGND VGND VDPWR VDPWR _1189_/A sky130_fd_sc_hd__nor4_1
XPHY_EDGE_ROW_37_2_2_Right_56 VGND VDPWR sky130_fd_sc_hd__tapvpwrvgnd_1
Xdelaybuf_13_clk delaybuf_13_clk/A VGND VGND VDPWR VDPWR delaybuf_13_clk/X sky130_fd_sc_hd__clkbuf_2
XFILLER_43_101 VGND VGND VDPWR VDPWR sky130_fd_sc_hd__fill_1
XFILLER_43_134 VGND VGND VDPWR VDPWR sky130_fd_sc_hd__decap_3
Xhold33 hold33/A VGND VGND VDPWR VDPWR hold33/X sky130_fd_sc_hd__dlygate4sd3_1
Xhold44 hold44/A VGND VGND VDPWR VDPWR hold44/X sky130_fd_sc_hd__dlygate4sd3_1
Xhold55 hold55/A VGND VGND VDPWR VDPWR hold55/X sky130_fd_sc_hd__dlygate4sd3_1
XFILLER_43_156 VGND VGND VDPWR VDPWR sky130_fd_sc_hd__decap_3
X_2050_ _2015_/B _1999_/X _2053_/B VGND VGND VDPWR VDPWR _2052_/A sky130_fd_sc_hd__o21a_1
XFILLER_19_197 VGND VGND VDPWR VDPWR sky130_fd_sc_hd__decap_3
XFILLER_34_134 VGND VGND VDPWR VDPWR sky130_fd_sc_hd__fill_2
X_1903_ _1904_/A _1903_/B VGND VGND VDPWR VDPWR _1903_/Y sky130_fd_sc_hd__nand2b_1
X_1834_ _1870_/C _1388_/Y _1832_/Y _1833_/Y VGND VGND VDPWR VDPWR _1834_/Y sky130_fd_sc_hd__o211ai_1
X_1765_ _2141_/Q _2140_/Q _1765_/C VGND VGND VDPWR VDPWR _1765_/Y sky130_fd_sc_hd__nor3_1
X_1696_ _1914_/S _1696_/B_N VGND VGND VDPWR VDPWR _1696_/Y sky130_fd_sc_hd__nor2b_1
X_2317_ _2317_/A VGND VGND VDPWR VDPWR uo_out[4] sky130_fd_sc_hd__buf_2
X_2248_ _2257_/CLK hold63/X _2123_/A VGND VGND VDPWR VDPWR hold55/A sky130_fd_sc_hd__dfrtp_1
X_2179_ _2179_/CLK _2179_/D VGND VGND VDPWR VDPWR _2179_/Q sky130_fd_sc_hd__dfxtp_1
XFILLER_40_137 VGND VGND VDPWR VDPWR sky130_fd_sc_hd__fill_2
XFILLER_48_248 VGND VGND VDPWR VDPWR sky130_fd_sc_hd__fill_1
XFILLER_56_53 VGND VGND VDPWR VDPWR sky130_fd_sc_hd__decap_3
XFILLER_71_273 VGND VGND VDPWR VDPWR sky130_fd_sc_hd__fill_2
X_1550_ _2235_/Q _1563_/B VGND VGND VDPWR VDPWR _1553_/A sky130_fd_sc_hd__nand2_1
X_1481_ _2034_/S _2206_/Q _1232_/A _2204_/Q VGND VGND VDPWR VDPWR _1481_/Y sky130_fd_sc_hd__o31ai_1
XFILLER_39_259 VGND VGND VDPWR VDPWR sky130_fd_sc_hd__fill_1
X_2102_ _2102_/A hold24/A VGND VGND VDPWR VDPWR _2217_/D sky130_fd_sc_hd__nor2b_1
X_2033_ _2034_/S hold64/A _2032_/Y VGND VGND VDPWR VDPWR _2033_/Y sky130_fd_sc_hd__a21oi_1
XFILLER_62_240 VGND VGND VDPWR VDPWR sky130_fd_sc_hd__fill_1
XFILLER_62_251 VGND VGND VDPWR VDPWR sky130_fd_sc_hd__decap_3
XTAP_TAPCELL_ROW_64_279 VGND VDPWR sky130_fd_sc_hd__tapvpwrvgnd_1
X_1817_ _2155_/Q _1824_/B VGND VGND VDPWR VDPWR _1817_/Y sky130_fd_sc_hd__nand2_1
X_1748_ _1748_/A _2014_/A VGND VGND VDPWR VDPWR _1950_/B sky130_fd_sc_hd__or2_1
X_1679_ _1881_/C _1675_/Y _1678_/Y VGND VGND VDPWR VDPWR _1904_/B sky130_fd_sc_hd__o21ai_1
XTAP_TAPCELL_ROW_55_235 VGND VDPWR sky130_fd_sc_hd__tapvpwrvgnd_1
Xu_sub.u_core.u_regfile.g_ir\[2\].u_lat wire103/X wire101/X wire100/X wire97/X wire95/X
+ max_cap93/X max_cap91/X max_cap89/X u_sub.u_core.u_regfile.g_ir\[2\].u_lat/GATE
+ VGND VDPWR _1063_/A _1294_/B _1401_/A _1367_/B _1648_/A0 _1152_/A _1152_/B _1399_/A
+ dlxtp8_x1
XFILLER_42_66 VGND VGND VDPWR VDPWR sky130_fd_sc_hd__fill_2
XFILLER_42_99 VGND VGND VDPWR VDPWR sky130_fd_sc_hd__fill_1
XPHY_EDGE_ROW_21_2_2_Right_40 VGND VDPWR sky130_fd_sc_hd__tapvpwrvgnd_1
XTAP_TAPCELL_ROW_78_349 VGND VDPWR sky130_fd_sc_hd__tapvpwrvgnd_1
Xclkbuf_3_1__f_clk_regs clkbuf_0_clk_regs/X VGND VGND VDPWR VDPWR clkload4/A sky130_fd_sc_hd__clkbuf_2
Xu_sub.u_core.u_regfile.g_nibsel\[4\].g_nib\[0\].u_lo u_sub.u_core.u_regfile.g_word\[4\].g_byte\[0\].u_lat/Q0
+ u_sub.u_core.u_regfile.g_word\[4\].g_byte\[0\].u_lat/Q4 u_sub.u_core.u_regfile.g_word\[4\].g_byte\[1\].u_lat/Q0
+ u_sub.u_core.u_regfile.g_word\[4\].g_byte\[1\].u_lat/Q4 max_cap6/X max_cap3/X VGND
+ VGND VDPWR VDPWR u_sub.u_core.u_regfile.g_nibsel\[4\].g_nib\[0\].u_lo/X tg_mux4_x1
X_1602_ _1605_/A _1605_/B _1607_/A VGND VGND VDPWR VDPWR _1602_/Y sky130_fd_sc_hd__nor3_1
XTAP_TAPCELL_ROW_69_305 VGND VDPWR sky130_fd_sc_hd__tapvpwrvgnd_1
Xu_sub.u_core.u_regfile.g_port\[1\].u_za u_sub.u_core.u_regfile.g_port\[1\].u_a/X
+ _1189_/C VGND VGND VDPWR VDPWR _1051_/A sky130_fd_sc_hd__and2_1
X_1533_ _2229_/Q _1533_/B VGND VGND VDPWR VDPWR _1538_/A sky130_fd_sc_hd__nand2_1
X_1464_ _1728_/B _1464_/B VGND VGND VDPWR VDPWR _1464_/Y sky130_fd_sc_hd__nand2_1
X_1395_ _2262_/Q _1395_/B _1541_/C VGND VGND VDPWR VDPWR _1395_/X sky130_fd_sc_hd__and3_1
X_2016_ _2204_/Q _1691_/B _2044_/B _2006_/X VGND VGND VDPWR VDPWR _2016_/Y sky130_fd_sc_hd__a31oi_1
XTAP_TAPCELL_ROW_60_260 VGND VDPWR sky130_fd_sc_hd__tapvpwrvgnd_1
Xhold130 _2225_/Q VGND VGND VDPWR VDPWR _1052_/A sky130_fd_sc_hd__dlygate4sd3_1
Xhold141 _2217_/Q VGND VGND VDPWR VDPWR _2102_/A sky130_fd_sc_hd__dlygate4sd3_1
XFILLER_18_229 VGND VGND VDPWR VDPWR sky130_fd_sc_hd__decap_3
XFILLER_41_243 VGND VGND VDPWR VDPWR sky130_fd_sc_hd__fill_1
XFILLER_5_188 VGND VGND VDPWR VDPWR sky130_fd_sc_hd__decap_3
XTAP_TAPCELL_ROW_74_330 VGND VDPWR sky130_fd_sc_hd__tapvpwrvgnd_1
X_1180_ _1399_/B _1399_/C _1179_/Y _1175_/B VGND VGND VDPWR VDPWR _1479_/A sky130_fd_sc_hd__o2bb2ai_1
XFILLER_64_1 VGND VGND VDPWR VDPWR sky130_fd_sc_hd__fill_2
X_1516_ _2233_/Q _1516_/B _1516_/C VGND VGND VDPWR VDPWR _1533_/B sky130_fd_sc_hd__nor3_1
X_1447_ _1488_/B _1855_/C VGND VGND VDPWR VDPWR _1517_/A sky130_fd_sc_hd__and2_1
X_1378_ _1578_/A _1375_/Y _1377_/Y _1572_/A VGND VGND VDPWR VDPWR _1379_/D sky130_fd_sc_hd__o22ai_1
XTAP_TAPCELL_ROW_80_366 VGND VDPWR sky130_fd_sc_hd__tapvpwrvgnd_1
XFILLER_61_305 VGND VGND VDPWR VDPWR sky130_fd_sc_hd__fill_1
Xmax_cap9 _1552_/A VGND VGND VDPWR VDPWR _1648_/S sky130_fd_sc_hd__buf_4
XFILLER_64_75 VGND VGND VDPWR VDPWR sky130_fd_sc_hd__decap_3
XFILLER_49_162 VGND VGND VDPWR VDPWR sky130_fd_sc_hd__fill_2
X_2281_ _2289_/CLK hold35/X VGND VGND VDPWR VDPWR hold30/A sky130_fd_sc_hd__dfxtp_1
Xclkbuf_leaf_1_clk clkbuf_leaf_4_clk/A VGND VGND VDPWR VDPWR clkbuf_leaf_1_clk/X sky130_fd_sc_hd__clkbuf_2
X_1301_ _1210_/Y _1300_/Y _1297_/Y VGND VGND VDPWR VDPWR _1301_/Y sky130_fd_sc_hd__a21oi_1
X_1232_ _1232_/A _1232_/B VGND VGND VDPWR VDPWR _1233_/B sky130_fd_sc_hd__nand2_1
XFILLER_64_198 VGND VGND VDPWR VDPWR sky130_fd_sc_hd__fill_2
X_1094_ _1214_/A _1200_/A _1137_/A VGND VGND VDPWR VDPWR _1097_/B sky130_fd_sc_hd__nor3b_1
X_1163_ _1395_/B _1148_/Y _1237_/C VGND VGND VDPWR VDPWR _1201_/A sky130_fd_sc_hd__o21ai_1
X_1996_ _1748_/A _1990_/B _2044_/B VGND VGND VDPWR VDPWR _1996_/Y sky130_fd_sc_hd__a21oi_1
XFILLER_55_143 VGND VGND VDPWR VDPWR sky130_fd_sc_hd__fill_1
XFILLER_50_66 VGND VGND VDPWR VDPWR sky130_fd_sc_hd__fill_2
Xclkload0 clkload0/A VGND VGND VDPWR VDPWR clkload0/Y sky130_fd_sc_hd__inv_12
Xwire126 _2134_/Q VGND VGND VDPWR VDPWR wire126/X sky130_fd_sc_hd__buf_12
XFILLER_59_97 VGND VGND VDPWR VDPWR sky130_fd_sc_hd__fill_2
XFILLER_34_327 VGND VGND VDPWR VDPWR sky130_fd_sc_hd__fill_2
XFILLER_46_121 VGND VGND VDPWR VDPWR sky130_fd_sc_hd__decap_3
XFILLER_46_187 VGND VGND VDPWR VDPWR sky130_fd_sc_hd__fill_1
XFILLER_46_198 VGND VGND VDPWR VDPWR sky130_fd_sc_hd__decap_3
XFILLER_61_124 VGND VGND VDPWR VDPWR sky130_fd_sc_hd__fill_2
XFILLER_61_146 VGND VGND VDPWR VDPWR sky130_fd_sc_hd__decap_3
XPHY_EDGE_ROW_18_2_2_Right_37 VGND VDPWR sky130_fd_sc_hd__tapvpwrvgnd_1
X_1850_ _2167_/Q wire69/X _1852_/S VGND VGND VDPWR VDPWR _2167_/D sky130_fd_sc_hd__mux2_1
X_1781_ _2143_/Q _1789_/B _1786_/C VGND VGND VDPWR VDPWR _1784_/A sky130_fd_sc_hd__a21oi_1
XFILLER_37_154 VGND VGND VDPWR VDPWR sky130_fd_sc_hd__decap_3
X_2264_ _2273_/CLK hold43/X VGND VGND VDPWR VDPWR hold52/A sky130_fd_sc_hd__dfxtp_1
X_2195_ clkload7/A _2195_/D VGND VGND VDPWR VDPWR _2195_/Q sky130_fd_sc_hd__dfxtp_1
X_1215_ _1209_/A _1376_/C _1212_/Y _1214_/Y _1210_/A VGND VGND VDPWR VDPWR _1215_/Y
+ sky130_fd_sc_hd__a221oi_1
X_1146_ _1449_/A _1592_/A _1146_/C VGND VGND VDPWR VDPWR _1202_/A sky130_fd_sc_hd__nor3_1
XFILLER_52_168 VGND VGND VDPWR VDPWR sky130_fd_sc_hd__fill_2
XFILLER_52_179 VGND VGND VDPWR VDPWR sky130_fd_sc_hd__decap_3
XTAP_TAPCELL_ROW_47_193 VGND VDPWR sky130_fd_sc_hd__tapvpwrvgnd_1
X_1077_ _1077_/A _1570_/A VGND VGND VDPWR VDPWR _1082_/B sky130_fd_sc_hd__nor2_1
X_1979_ _2192_/Q _1979_/B _1979_/C VGND VGND VDPWR VDPWR _1979_/Y sky130_fd_sc_hd__nand3_1
Xhold34 hold34/A VGND VGND VDPWR VDPWR hold34/X sky130_fd_sc_hd__dlygate4sd3_1
Xhold45 hold45/A VGND VGND VDPWR VDPWR hold45/X sky130_fd_sc_hd__dlygate4sd3_1
Xhold56 hold56/A VGND VGND VDPWR VDPWR hold56/X sky130_fd_sc_hd__dlygate4sd3_1
XFILLER_43_146 VGND VGND VDPWR VDPWR sky130_fd_sc_hd__fill_1
XFILLER_45_99 VGND VGND VDPWR VDPWR sky130_fd_sc_hd__decap_3
XFILLER_61_10 VGND VGND VDPWR VDPWR sky130_fd_sc_hd__decap_3
XFILLER_3_220 VGND VGND VDPWR VDPWR sky130_fd_sc_hd__fill_1
XFILLER_3_231 VGND VGND VDPWR VDPWR sky130_fd_sc_hd__decap_3
Xdelaybuf_6_clk delaybuf_6_clk/A VGND VGND VDPWR VDPWR delaybuf_7_clk/A sky130_fd_sc_hd__clkbuf_2
XFILLER_66_205 VGND VGND VDPWR VDPWR sky130_fd_sc_hd__decap_3
XFILLER_66_227 VGND VGND VDPWR VDPWR sky130_fd_sc_hd__fill_2
XFILLER_34_146 VGND VGND VDPWR VDPWR sky130_fd_sc_hd__fill_1
X_1902_ _1902_/A _1902_/B VGND VGND VDPWR VDPWR _1907_/B sky130_fd_sc_hd__nor2_1
X_1833_ _1833_/A _1833_/B VGND VGND VDPWR VDPWR _1833_/Y sky130_fd_sc_hd__nand2_1
X_1764_ _2144_/Q _2145_/Q _2143_/Q _2142_/Q VGND VGND VDPWR VDPWR _1765_/C sky130_fd_sc_hd__nand4b_1
X_2316_ _2316_/A VGND VGND VDPWR VDPWR uo_out[3] sky130_fd_sc_hd__buf_2
X_1695_ _1499_/C _1689_/X _1694_/Y VGND VGND VDPWR VDPWR _1695_/Y sky130_fd_sc_hd__o21ai_1
X_2247_ _2258_/CLK hold57/X _2123_/A VGND VGND VDPWR VDPWR hold61/A sky130_fd_sc_hd__dfrtp_1
X_2178_ _2178_/CLK _2178_/D VGND VGND VDPWR VDPWR wire92/A sky130_fd_sc_hd__dfxtp_1
X_1129_ _1211_/A _1129_/B VGND VGND VDPWR VDPWR _1205_/A sky130_fd_sc_hd__nand2_1
XFILLER_48_205 VGND VGND VDPWR VDPWR sky130_fd_sc_hd__fill_1
Xclkbuf_3_0__f_clk_regs clkbuf_0_clk_regs/X VGND VGND VDPWR VDPWR clkload3/A sky130_fd_sc_hd__clkbuf_2
XFILLER_71_230 VGND VGND VDPWR VDPWR sky130_fd_sc_hd__decap_3
Xu_sub.u_core.u_regfile.g_port\[3\].u_a u_sub.u_core.u_regfile.g_port\[3\].u_b/A0
+ u_sub.u_core.u_regfile.g_port\[3\].u_b/A1 u_sub.u_core.u_regfile.g_port\[3\].u_b/A2
+ u_sub.u_core.u_regfile.g_port\[3\].u_b/A3 wire88/X _1478_/X VGND VGND VDPWR VDPWR
+ u_sub.u_core.u_regfile.g_port\[3\].u_a/X tg_mux4_x1
X_1480_ _2034_/S _1480_/B _2204_/Q VGND VGND VDPWR VDPWR _1480_/Y sky130_fd_sc_hd__nor3_1
XFILLER_39_227 VGND VGND VDPWR VDPWR sky130_fd_sc_hd__fill_2
X_2101_ _2101_/A _2123_/A VGND VGND VDPWR VDPWR _2216_/D sky130_fd_sc_hd__nor2b_1
X_2032_ _2034_/S hold38/A VGND VGND VDPWR VDPWR _2032_/Y sky130_fd_sc_hd__nor2b_1
XFILLER_62_285 VGND VGND VDPWR VDPWR sky130_fd_sc_hd__fill_2
X_1816_ _2154_/Q _1814_/Y _1815_/Y VGND VGND VDPWR VDPWR _2154_/D sky130_fd_sc_hd__o21ai_1
X_1747_ _1748_/A _2014_/A VGND VGND VDPWR VDPWR _1951_/B sky130_fd_sc_hd__nor2_1
X_1678_ _1881_/C _1678_/B VGND VGND VDPWR VDPWR _1678_/Y sky130_fd_sc_hd__nand2_1
XTAP_TAPCELL_ROW_55_236 VGND VDPWR sky130_fd_sc_hd__tapvpwrvgnd_1
XFILLER_42_78 VGND VGND VDPWR VDPWR sky130_fd_sc_hd__fill_2
XFILLER_44_230 VGND VGND VDPWR VDPWR sky130_fd_sc_hd__decap_3
XFILLER_67_64 VGND VGND VDPWR VDPWR sky130_fd_sc_hd__fill_2
XFILLER_67_75 VGND VGND VDPWR VDPWR sky130_fd_sc_hd__decap_3
XPHY_EDGE_ROW_42_Right_61 VGND VDPWR sky130_fd_sc_hd__tapvpwrvgnd_1
XPHY_EDGE_ROW_51_Right_70 VGND VDPWR sky130_fd_sc_hd__tapvpwrvgnd_1
X_1601_ _1601_/A _1601_/B _1601_/C VGND VGND VDPWR VDPWR _1601_/X sky130_fd_sc_hd__and3_1
X_1532_ _1532_/A _1532_/B VGND VGND VDPWR VDPWR _2229_/D sky130_fd_sc_hd__nand2_1
XTAP_TAPCELL_ROW_69_306 VGND VDPWR sky130_fd_sc_hd__tapvpwrvgnd_1
Xu_sub.u_core.u_regfile.g_port\[1\].u_zb u_sub.u_core.u_regfile.g_port\[1\].u_b/X
+ _1181_/X VGND VGND VDPWR VDPWR wire69/A sky130_fd_sc_hd__and2_1
X_1463_ _1848_/B _2236_/Q VGND VGND VDPWR VDPWR _1464_/B sky130_fd_sc_hd__nand2_1
X_1394_ _1393_/B _1392_/Y _1393_/Y VGND VGND VDPWR VDPWR _1394_/Y sky130_fd_sc_hd__a21oi_1
XFILLER_50_211 VGND VGND VDPWR VDPWR sky130_fd_sc_hd__decap_3
XTAP_TAPCELL_ROW_52_217 VGND VDPWR sky130_fd_sc_hd__tapvpwrvgnd_1
X_2015_ _2205_/Q _2015_/B _2015_/C VGND VGND VDPWR VDPWR _2015_/Y sky130_fd_sc_hd__nor3_1
XTAP_TAPCELL_ROW_60_261 VGND VDPWR sky130_fd_sc_hd__tapvpwrvgnd_1
Xhold131 _2313_/A VGND VGND VDPWR VDPWR hold131/X sky130_fd_sc_hd__dlygate4sd3_1
XFILLER_37_89 VGND VGND VDPWR VDPWR sky130_fd_sc_hd__decap_3
XFILLER_41_222 VGND VGND VDPWR VDPWR sky130_fd_sc_hd__decap_3
XFILLER_53_99 VGND VGND VDPWR VDPWR sky130_fd_sc_hd__decap_3
XPHY_EDGE_ROW_20_2_2_Left_9 VGND VDPWR sky130_fd_sc_hd__tapvpwrvgnd_1
XTAP_TAPCELL_ROW_74_331 VGND VDPWR sky130_fd_sc_hd__tapvpwrvgnd_1
Xu_sub.u_core.u_regfile.g_nibsel\[1\].g_nib\[1\].u_lo u_sub.u_core.u_regfile.g_word\[1\].g_byte\[0\].u_lat/Q1
+ u_sub.u_core.u_regfile.g_word\[1\].g_byte\[0\].u_lat/Q5 u_sub.u_core.u_regfile.g_word\[1\].g_byte\[1\].u_lat/Q1
+ u_sub.u_core.u_regfile.g_word\[1\].g_byte\[1\].u_lat/Q5 max_cap6/X max_cap3/X VGND
+ VGND VDPWR VDPWR u_sub.u_core.u_regfile.g_nibsel\[1\].g_nib\[1\].u_lo/X tg_mux4_x1
XFILLER_57_1 VGND VGND VDPWR VDPWR sky130_fd_sc_hd__fill_1
X_1515_ _1232_/A _1513_/Y _1514_/Y VGND VGND VDPWR VDPWR _1516_/C sky130_fd_sc_hd__a21oi_1
XFILLER_55_325 VGND VGND VDPWR VDPWR sky130_fd_sc_hd__fill_2
XFILLER_67_174 VGND VGND VDPWR VDPWR sky130_fd_sc_hd__decap_3
X_1446_ _1521_/A _1855_/C VGND VGND VDPWR VDPWR _1826_/C sky130_fd_sc_hd__nor2_1
X_1377_ _1187_/D _1221_/B _1377_/B1 VGND VGND VDPWR VDPWR _1377_/Y sky130_fd_sc_hd__a21oi_1
XFILLER_23_222 VGND VGND VDPWR VDPWR sky130_fd_sc_hd__decap_3
XFILLER_70_339 VGND VGND VDPWR VDPWR sky130_fd_sc_hd__fill_1
XFILLER_48_66 VGND VGND VDPWR VDPWR sky130_fd_sc_hd__fill_2
XFILLER_14_200 VGND VGND VDPWR VDPWR sky130_fd_sc_hd__decap_3
XFILLER_58_196 VGND VGND VDPWR VDPWR sky130_fd_sc_hd__decap_3
XFILLER_61_328 VGND VGND VDPWR VDPWR sky130_fd_sc_hd__fill_1
XTAP_TAPCELL_ROW_71_312 VGND VDPWR sky130_fd_sc_hd__tapvpwrvgnd_1
XFILLER_14_233 VGND VGND VDPWR VDPWR sky130_fd_sc_hd__decap_3
XFILLER_49_130 VGND VGND VDPWR VDPWR sky130_fd_sc_hd__decap_3
XFILLER_49_174 VGND VGND VDPWR VDPWR sky130_fd_sc_hd__decap_3
XFILLER_49_196 VGND VGND VDPWR VDPWR sky130_fd_sc_hd__decap_3
XFILLER_64_100 VGND VGND VDPWR VDPWR sky130_fd_sc_hd__fill_1
X_2280_ _2289_/CLK hold32/X VGND VGND VDPWR VDPWR hold34/A sky130_fd_sc_hd__dfxtp_1
X_1300_ _1848_/A _1195_/A _1299_/Y VGND VGND VDPWR VDPWR _1300_/Y sky130_fd_sc_hd__o21ai_1
X_1231_ _1237_/A _1231_/B VGND VGND VDPWR VDPWR _1656_/B sky130_fd_sc_hd__nor2_1
X_1162_ _1162_/A _1162_/B VGND VGND VDPWR VDPWR _1199_/A sky130_fd_sc_hd__and2_1
X_1093_ _1141_/A VGND VGND VDPWR VDPWR _1093_/Y sky130_fd_sc_hd__inv_1
X_1995_ hold44/A _2034_/S _2048_/C _1993_/Y VGND VGND VDPWR VDPWR _1995_/Y sky130_fd_sc_hd__o211ai_1
X_1429_ _2131_/Q _1429_/A2 _2117_/A _1428_/Y _1429_/B2 VGND VGND VDPWR VDPWR _1430_/B
+ sky130_fd_sc_hd__a32oi_1
Xu_sub.u_core.u_regfile.g_word\[2\].g_byte\[1\].u_lat wire103/X wire101/X wire100/X
+ wire97/X wire95/X max_cap93/X max_cap91/X max_cap89/X u_sub.u_core.u_regfile.g_word\[2\].g_byte\[1\].u_lat/GATE
+ VGND VDPWR u_sub.u_core.u_regfile.g_word\[2\].g_byte\[1\].u_lat/Q0 u_sub.u_core.u_regfile.g_word\[2\].g_byte\[1\].u_lat/Q1
+ u_sub.u_core.u_regfile.g_word\[2\].g_byte\[1\].u_lat/Q2 u_sub.u_core.u_regfile.g_word\[2\].g_byte\[1\].u_lat/Q3
+ u_sub.u_core.u_regfile.g_word\[2\].g_byte\[1\].u_lat/Q4 u_sub.u_core.u_regfile.g_word\[2\].g_byte\[1\].u_lat/Q5
+ u_sub.u_core.u_regfile.g_word\[2\].g_byte\[1\].u_lat/Q6 u_sub.u_core.u_regfile.g_word\[2\].g_byte\[1\].u_lat/Q7
+ dlxtp8_x1
Xclkload1 clkload1/A VGND VGND VDPWR VDPWR clkload1/Y sky130_fd_sc_hd__inv_12
XFILLER_46_111 VGND VGND VDPWR VDPWR sky130_fd_sc_hd__fill_1
XFILLER_34_339 VGND VGND VDPWR VDPWR sky130_fd_sc_hd__fill_1
XFILLER_46_144 VGND VGND VDPWR VDPWR sky130_fd_sc_hd__decap_3
XFILLER_46_155 VGND VGND VDPWR VDPWR sky130_fd_sc_hd__decap_3
XFILLER_61_103 VGND VGND VDPWR VDPWR sky130_fd_sc_hd__fill_1
XFILLER_61_158 VGND VGND VDPWR VDPWR sky130_fd_sc_hd__fill_1
X_1780_ _1780_/A _1786_/C _2123_/A VGND VGND VDPWR VDPWR _2142_/D sky130_fd_sc_hd__nor3b_1
XFILLER_52_125 VGND VGND VDPWR VDPWR sky130_fd_sc_hd__fill_2
X_2263_ _2274_/CLK hold44/X VGND VGND VDPWR VDPWR hold41/A sky130_fd_sc_hd__dfxtp_1
X_2194_ clkload7/A _2194_/D VGND VGND VDPWR VDPWR _2194_/Q sky130_fd_sc_hd__dfxtp_1
X_1214_ _1214_/A _1214_/B _1214_/C _1214_/D VGND VGND VDPWR VDPWR _1214_/Y sky130_fd_sc_hd__nor4_1
X_1145_ _1591_/A _1605_/A VGND VGND VDPWR VDPWR _1146_/C sky130_fd_sc_hd__nand2_1
XFILLER_52_147 VGND VGND VDPWR VDPWR sky130_fd_sc_hd__decap_3
XTAP_TAPCELL_ROW_47_194 VGND VDPWR sky130_fd_sc_hd__tapvpwrvgnd_1
X_1076_ _1082_/A VGND VGND VDPWR VDPWR _1591_/A sky130_fd_sc_hd__inv_1
X_1978_ _1982_/C _1977_/Y _1803_/A VGND VGND VDPWR VDPWR _2194_/D sky130_fd_sc_hd__a21boi_1
XFILLER_68_291 VGND VGND VDPWR VDPWR sky130_fd_sc_hd__fill_2
Xhold24 hold24/A VGND VGND VDPWR VDPWR hold24/X sky130_fd_sc_hd__dlygate4sd3_1
Xhold35 hold35/A VGND VGND VDPWR VDPWR hold35/X sky130_fd_sc_hd__dlygate4sd3_1
Xhold46 hold46/A VGND VGND VDPWR VDPWR hold46/X sky130_fd_sc_hd__dlygate4sd3_1
Xhold57 hold57/A VGND VGND VDPWR VDPWR hold57/X sky130_fd_sc_hd__dlygate4sd3_1
XFILLER_28_188 VGND VGND VDPWR VDPWR sky130_fd_sc_hd__decap_3
XFILLER_43_103 VGND VGND VDPWR VDPWR sky130_fd_sc_hd__decap_3
XFILLER_45_78 VGND VGND VDPWR VDPWR sky130_fd_sc_hd__fill_2
XFILLER_61_44 VGND VGND VDPWR VDPWR sky130_fd_sc_hd__decap_3
XFILLER_19_188 VGND VGND VDPWR VDPWR sky130_fd_sc_hd__decap_3
XFILLER_66_239 VGND VGND VDPWR VDPWR sky130_fd_sc_hd__decap_3
X_1901_ _2125_/A _2124_/B VGND VGND VDPWR VDPWR _2173_/D sky130_fd_sc_hd__nor2_1
X_1832_ _1832_/A _1832_/B VGND VGND VDPWR VDPWR _1832_/Y sky130_fd_sc_hd__nand2_1
X_1763_ _1763_/A _1763_/B VGND VGND VDPWR VDPWR _2137_/D sky130_fd_sc_hd__nor2_1
X_1694_ _2224_/Q _2116_/C _1693_/Y VGND VGND VDPWR VDPWR _1694_/Y sky130_fd_sc_hd__a21oi_1
X_2315_ _2315_/A VGND VGND VDPWR VDPWR uo_out[0] sky130_fd_sc_hd__buf_2
X_2246_ _2258_/CLK hold64/X hold24/X VGND VGND VDPWR VDPWR _2246_/Q sky130_fd_sc_hd__dfrtp_1
XFILLER_40_106 VGND VGND VDPWR VDPWR sky130_fd_sc_hd__decap_3
XFILLER_40_117 VGND VGND VDPWR VDPWR sky130_fd_sc_hd__decap_3
XFILLER_65_272 VGND VGND VDPWR VDPWR sky130_fd_sc_hd__decap_3
X_1059_ _2155_/Q _1638_/A VGND VGND VDPWR VDPWR _1257_/B sky130_fd_sc_hd__or2_1
X_2177_ _2178_/CLK _2177_/D VGND VGND VDPWR VDPWR _2177_/Q sky130_fd_sc_hd__dfxtp_1
X_1128_ _2171_/Q _1128_/B VGND VGND VDPWR VDPWR _1129_/B sky130_fd_sc_hd__nand2_1
XFILLER_24_191 VGND VGND VDPWR VDPWR sky130_fd_sc_hd__decap_3
XFILLER_71_242 VGND VGND VDPWR VDPWR sky130_fd_sc_hd__decap_3
XFILLER_71_264 VGND VGND VDPWR VDPWR sky130_fd_sc_hd__fill_2
Xu_sub.u_core.u_regfile.g_port\[3\].u_b u_sub.u_core.u_regfile.g_port\[3\].u_b/A0
+ u_sub.u_core.u_regfile.g_port\[3\].u_b/A1 u_sub.u_core.u_regfile.g_port\[3\].u_b/A2
+ u_sub.u_core.u_regfile.g_port\[3\].u_b/A3 _1400_/X _1479_/Y VGND VGND VDPWR VDPWR
+ u_sub.u_core.u_regfile.g_port\[3\].u_b/X tg_mux4_x1
X_2100_ _2060_/Y _2090_/X _2099_/Y _1612_/B _2216_/Q VGND VGND VDPWR VDPWR _2101_/A
+ sky130_fd_sc_hd__a32oi_1
X_2031_ uio_out[3] _2197_/D VGND VGND VDPWR VDPWR _2031_/Y sky130_fd_sc_hd__nand2_1
XFILLER_15_191 VGND VGND VDPWR VDPWR sky130_fd_sc_hd__decap_3
XFILLER_30_194 VGND VGND VDPWR VDPWR sky130_fd_sc_hd__decap_3
X_1815_ _2154_/Q _1824_/B VGND VGND VDPWR VDPWR _1815_/Y sky130_fd_sc_hd__nand2_1
Xu_sub.u_core.u_regfile.g_nibsel\[2\].g_nib\[3\].u_m2 u_sub.u_core.u_regfile.g_nibsel\[2\].g_nib\[3\].u_lo/X
+ u_sub.u_core.u_regfile.g_nibsel\[2\].g_nib\[3\].u_hi/X wire76/X VGND VGND VDPWR
+ VDPWR u_sub.u_core.u_regfile.g_port\[3\].u_b/A1 sky130_fd_sc_hd__mux2_1
X_1746_ _2133_/Q _1744_/Y _1730_/X VGND VGND VDPWR VDPWR _2133_/D sky130_fd_sc_hd__o21a_1
X_1677_ wire85/X _1666_/B _1676_/Y VGND VGND VDPWR VDPWR _1678_/B sky130_fd_sc_hd__o21ai_1
X_2229_ clkload7/A _2229_/D _2291_/D VGND VGND VDPWR VDPWR _2229_/Q sky130_fd_sc_hd__dfrtp_1
XFILLER_38_283 VGND VGND VDPWR VDPWR sky130_fd_sc_hd__fill_2
XFILLER_67_10 VGND VGND VDPWR VDPWR sky130_fd_sc_hd__decap_3
XFILLER_32_90 VGND VGND VDPWR VDPWR sky130_fd_sc_hd__decap_3
X_1600_ _1601_/A _1600_/B _1601_/C VGND VGND VDPWR VDPWR _1600_/X sky130_fd_sc_hd__and3_1
X_1531_ _1531_/A _1531_/B VGND VGND VDPWR VDPWR _1532_/B sky130_fd_sc_hd__nand2_1
X_1462_ _1455_/Y _1606_/B _1581_/A VGND VGND VDPWR VDPWR _1462_/Y sky130_fd_sc_hd__o21ai_1
X_1393_ _2278_/Q _1393_/B VGND VGND VDPWR VDPWR _1393_/Y sky130_fd_sc_hd__nor2_1
XTAP_TAPCELL_ROW_52_218 VGND VDPWR sky130_fd_sc_hd__tapvpwrvgnd_1
X_2014_ _2014_/A _2036_/B VGND VGND VDPWR VDPWR _2015_/C sky130_fd_sc_hd__nor2_1
XFILLER_58_312 VGND VGND VDPWR VDPWR sky130_fd_sc_hd__fill_1
Xhold132 _2001_/A VGND VGND VDPWR VDPWR hold132/X sky130_fd_sc_hd__dlygate4sd3_1
Xhold143 _2169_/Q VGND VGND VDPWR VDPWR hold143/X sky130_fd_sc_hd__dlygate4sd3_1
X_1729_ _1729_/A _1729_/B VGND VGND VDPWR VDPWR _2290_/D sky130_fd_sc_hd__nor2_1
XFILLER_37_35 VGND VGND VDPWR VDPWR sky130_fd_sc_hd__fill_2
Xu_sub.u_core.u_regfile.g_port\[2\].u_a u_sub.u_core.u_regfile.g_port\[2\].u_b/A0
+ u_sub.u_core.u_regfile.g_port\[2\].u_b/A1 u_sub.u_core.u_regfile.g_port\[2\].u_b/A2
+ u_sub.u_core.u_regfile.g_port\[2\].u_b/A3 wire88/X _1478_/X VGND VGND VDPWR VDPWR
+ u_sub.u_core.u_regfile.g_port\[2\].u_a/X tg_mux4_x1
XFILLER_41_212 VGND VGND VDPWR VDPWR sky130_fd_sc_hd__decap_3
XFILLER_71_4 VGND VGND VDPWR VDPWR sky130_fd_sc_hd__decap_3
X_1514_ _2154_/Q _2237_/Q _1682_/A VGND VGND VDPWR VDPWR _1514_/Y sky130_fd_sc_hd__nand3_1
X_1445_ _1486_/C _1444_/Y wire77/X VGND VGND VDPWR VDPWR _1855_/C sky130_fd_sc_hd__a21boi_1
XFILLER_67_153 VGND VGND VDPWR VDPWR sky130_fd_sc_hd__fill_2
XFILLER_67_186 VGND VGND VDPWR VDPWR sky130_fd_sc_hd__fill_2
X_1376_ _1376_/A _1376_/B _1376_/C VGND VGND VDPWR VDPWR _1379_/C sky130_fd_sc_hd__and3_1
XFILLER_23_234 VGND VGND VDPWR VDPWR sky130_fd_sc_hd__fill_2
XFILLER_70_329 VGND VGND VDPWR VDPWR sky130_fd_sc_hd__fill_2
XTAP_TAPCELL_ROW_80_357 VGND VDPWR sky130_fd_sc_hd__tapvpwrvgnd_1
XFILLER_58_175 VGND VGND VDPWR VDPWR sky130_fd_sc_hd__decap_3
XPHY_EDGE_ROW_70_Right_89 VGND VDPWR sky130_fd_sc_hd__tapvpwrvgnd_1
XFILLER_14_212 VGND VGND VDPWR VDPWR sky130_fd_sc_hd__decap_3
XPHY_EDGE_ROW_33_2_2_Right_52 VGND VDPWR sky130_fd_sc_hd__tapvpwrvgnd_1
XTAP_TAPCELL_ROW_71_313 VGND VDPWR sky130_fd_sc_hd__tapvpwrvgnd_1
X_1092_ _1135_/B _1214_/B VGND VGND VDPWR VDPWR _1141_/A sky130_fd_sc_hd__nor2_1
X_1230_ _1251_/A _1251_/B VGND VGND VDPWR VDPWR _1271_/B sky130_fd_sc_hd__or2_1
X_1161_ _1480_/B _1189_/B _1168_/D _1157_/Y VGND VGND VDPWR VDPWR _1162_/B sky130_fd_sc_hd__o211ai_1
X_1994_ _2204_/Q _1992_/Y _1990_/Y _2044_/B VGND VGND VDPWR VDPWR _1994_/Y sky130_fd_sc_hd__o211ai_1
X_1428_ _2117_/A _1795_/A VGND VGND VDPWR VDPWR _1428_/Y sky130_fd_sc_hd__nor2_1
XFILLER_43_307 VGND VGND VDPWR VDPWR sky130_fd_sc_hd__fill_1
XFILLER_70_126 VGND VGND VDPWR VDPWR sky130_fd_sc_hd__fill_1
XFILLER_70_137 VGND VGND VDPWR VDPWR sky130_fd_sc_hd__fill_1
X_1359_ hold129/X _1321_/Y _1358_/Y _1727_/B VGND VGND VDPWR VDPWR _2257_/D sky130_fd_sc_hd__o22ai_1
XFILLER_11_204 VGND VGND VDPWR VDPWR sky130_fd_sc_hd__fill_1
Xclkload2 u_adc/clk VGND VGND VDPWR VDPWR clkload2/Y sky130_fd_sc_hd__inv_12
Xdelaybuf_16_clk clkbuf_0_clk/X VGND VGND VDPWR VDPWR delaybuf_17_clk/A sky130_fd_sc_hd__clkbuf_2
XFILLER_46_134 VGND VGND VDPWR VDPWR sky130_fd_sc_hd__fill_2
XFILLER_61_137 VGND VGND VDPWR VDPWR sky130_fd_sc_hd__decap_3
Xu_sub.u_core.u_regfile.g_word\[4\].g_byte\[2\].u_cg.u_icg clkbuf_leaf_2_clk/X _1604_/Y
+ VGND VGND VDPWR VDPWR u_sub.u_core.u_regfile.g_word\[4\].g_byte\[2\].u_lat/GATE
+ sky130_fd_sc_hd__dlclkp_1
XFILLER_69_226 VGND VGND VDPWR VDPWR sky130_fd_sc_hd__decap_3
X_2262_ _2274_/CLK hold38/X VGND VGND VDPWR VDPWR _2262_/Q sky130_fd_sc_hd__dfxtp_1
X_1213_ _1914_/S _1213_/B VGND VGND VDPWR VDPWR _1214_/D sky130_fd_sc_hd__nor2_1
XFILLER_52_137 VGND VGND VDPWR VDPWR sky130_fd_sc_hd__decap_3
XTAP_TAPCELL_ROW_47_195 VGND VDPWR sky130_fd_sc_hd__tapvpwrvgnd_1
X_1075_ _1075_/A _1144_/A _1075_/C _1144_/B VGND VGND VDPWR VDPWR _1082_/A sky130_fd_sc_hd__nor4_1
X_2193_ clkload4/A _2193_/D VGND VGND VDPWR VDPWR _2193_/Q sky130_fd_sc_hd__dfxtp_1
X_1144_ _1144_/A _1144_/B _1144_/C VGND VGND VDPWR VDPWR _1605_/A sky130_fd_sc_hd__nand3_1
X_1977_ _2226_/Q _2193_/Q VGND VGND VDPWR VDPWR _1977_/Y sky130_fd_sc_hd__nand2_1
XPHY_EDGE_ROW_20_2_2_Right_39 VGND VDPWR sky130_fd_sc_hd__tapvpwrvgnd_1
Xhold25 hold25/A VGND VGND VDPWR VDPWR hold25/X sky130_fd_sc_hd__dlygate4sd3_1
Xhold36 hold36/A VGND VGND VDPWR VDPWR hold36/X sky130_fd_sc_hd__dlygate4sd3_1
Xhold47 hold47/A VGND VGND VDPWR VDPWR hold47/X sky130_fd_sc_hd__dlygate4sd3_1
Xhold58 hold58/A VGND VGND VDPWR VDPWR hold58/X sky130_fd_sc_hd__dlygate4sd3_1
XFILLER_43_115 VGND VGND VDPWR VDPWR sky130_fd_sc_hd__fill_2
XFILLER_43_137 VGND VGND VDPWR VDPWR sky130_fd_sc_hd__fill_1
XFILLER_43_159 VGND VGND VDPWR VDPWR sky130_fd_sc_hd__fill_2
XFILLER_45_35 VGND VGND VDPWR VDPWR sky130_fd_sc_hd__decap_3
XFILLER_51_181 VGND VGND VDPWR VDPWR sky130_fd_sc_hd__fill_2
X_1900_ _1907_/A _1876_/Y _1888_/Y _1899_/Y _1921_/A VGND VGND VDPWR VDPWR _2124_/B
+ sky130_fd_sc_hd__o32ai_1
X_1831_ _2159_/Q _1830_/B _1830_/Y VGND VGND VDPWR VDPWR _2159_/D sky130_fd_sc_hd__a21o_1
X_1762_ wire67/X _1762_/B VGND VGND VDPWR VDPWR _1763_/B sky130_fd_sc_hd__nor2_1
X_1693_ _1965_/C _1693_/B VGND VGND VDPWR VDPWR _1693_/Y sky130_fd_sc_hd__nor2_1
XFILLER_32_1 VGND VGND VDPWR VDPWR sky130_fd_sc_hd__decap_3
XFILLER_57_207 VGND VGND VDPWR VDPWR sky130_fd_sc_hd__fill_2
X_2314_ _2314_/A VGND VGND VDPWR VDPWR uio_out[5] sky130_fd_sc_hd__buf_2
X_2245_ _2258_/CLK hold56/X _2123_/A VGND VGND VDPWR VDPWR _2245_/Q sky130_fd_sc_hd__dfrtp_1
X_2176_ _2179_/CLK _2176_/D VGND VGND VDPWR VDPWR _2176_/Q sky130_fd_sc_hd__dfxtp_1
X_1058_ _2155_/Q _1638_/A VGND VGND VDPWR VDPWR _1495_/A sky130_fd_sc_hd__nor2_1
X_1127_ _1168_/B _1135_/B VGND VGND VDPWR VDPWR _1128_/B sky130_fd_sc_hd__nor2_1
XFILLER_56_78 VGND VGND VDPWR VDPWR sky130_fd_sc_hd__decap_3
XFILLER_71_221 VGND VGND VDPWR VDPWR sky130_fd_sc_hd__decap_3
Xu_sub.u_core.u_regfile.g_nibsel\[3\].g_nib\[1\].u_m2 u_sub.u_core.u_regfile.g_nibsel\[3\].g_nib\[1\].u_lo/X
+ u_sub.u_core.u_regfile.g_nibsel\[3\].g_nib\[1\].u_hi/X wire76/X VGND VGND VDPWR
+ VDPWR u_sub.u_core.u_regfile.g_port\[1\].u_b/A2 sky130_fd_sc_hd__mux2_1
XTAP_TAPCELL_ROW_66_290 VGND VDPWR sky130_fd_sc_hd__tapvpwrvgnd_1
XTAP_TAPCELL_ROW_49_202 VGND VDPWR sky130_fd_sc_hd__tapvpwrvgnd_1
X_2030_ _2004_/A _2029_/Y _2020_/Y VGND VGND VDPWR VDPWR _2200_/D sky130_fd_sc_hd__o21ai_1
XFILLER_62_254 VGND VGND VDPWR VDPWR sky130_fd_sc_hd__fill_1
Xmax_cap90 _2179_/Q VGND VGND VDPWR VDPWR max_cap90/X sky130_fd_sc_hd__clkbuf_8
X_1814_ _1814_/A _1814_/B _1814_/C VGND VGND VDPWR VDPWR _1814_/Y sky130_fd_sc_hd__nand3_1
X_1745_ _2132_/Q _1744_/Y _1730_/X VGND VGND VDPWR VDPWR _2132_/D sky130_fd_sc_hd__o21a_1
X_1676_ _2162_/Q wire85/X VGND VGND VDPWR VDPWR _1676_/Y sky130_fd_sc_hd__nand2_1
XFILLER_38_251 VGND VGND VDPWR VDPWR sky130_fd_sc_hd__decap_3
XFILLER_38_273 VGND VGND VDPWR VDPWR sky130_fd_sc_hd__fill_1
XFILLER_38_295 VGND VGND VDPWR VDPWR sky130_fd_sc_hd__fill_1
X_2228_ _2291_/CLK _2228_/D _2291_/D VGND VGND VDPWR VDPWR _2228_/Q sky130_fd_sc_hd__dfstp_2
X_2159_ clkload7/A _2159_/D _2291_/D VGND VGND VDPWR VDPWR _2159_/Q sky130_fd_sc_hd__dfrtp_1
XPHY_EDGE_ROW_79_Left_138 VGND VDPWR sky130_fd_sc_hd__tapvpwrvgnd_1
XFILLER_32_80 VGND VGND VDPWR VDPWR sky130_fd_sc_hd__decap_3
X_1530_ _1564_/C VGND VGND VDPWR VDPWR _1531_/B sky130_fd_sc_hd__inv_1
X_1461_ _1455_/Y _1459_/Y _1581_/A VGND VGND VDPWR VDPWR _1461_/Y sky130_fd_sc_hd__o21ai_1
X_1392_ _1266_/X _1870_/C _1391_/X VGND VGND VDPWR VDPWR _1392_/Y sky130_fd_sc_hd__o21ai_1
X_2013_ _2048_/C _2013_/B VGND VGND VDPWR VDPWR _2013_/Y sky130_fd_sc_hd__nand2_1
XTAP_TAPCELL_ROW_52_219 VGND VDPWR sky130_fd_sc_hd__tapvpwrvgnd_1
Xhold133 _2130_/Q VGND VGND VDPWR VDPWR _1938_/A sky130_fd_sc_hd__dlygate4sd3_1
Xhold144 _2217_/Q VGND VGND VDPWR VDPWR hold144/X sky130_fd_sc_hd__dlygate4sd3_1
X_1728_ _2246_/Q _1728_/B VGND VGND VDPWR VDPWR _1729_/B sky130_fd_sc_hd__nor2_1
Xu_sub.u_core.u_regfile.g_port\[2\].u_b u_sub.u_core.u_regfile.g_port\[2\].u_b/A0
+ u_sub.u_core.u_regfile.g_port\[2\].u_b/A1 u_sub.u_core.u_regfile.g_port\[2\].u_b/A2
+ u_sub.u_core.u_regfile.g_port\[2\].u_b/A3 _1400_/X _1479_/Y VGND VGND VDPWR VDPWR
+ u_sub.u_core.u_regfile.g_port\[2\].u_b/X tg_mux4_x1
X_1659_ _2164_/Q wire85/X _1658_/Y VGND VGND VDPWR VDPWR _1659_/Y sky130_fd_sc_hd__o21ai_1
XFILLER_53_35 VGND VGND VDPWR VDPWR sky130_fd_sc_hd__fill_2
XFILLER_41_268 VGND VGND VDPWR VDPWR sky130_fd_sc_hd__decap_3
XPHY_EDGE_ROW_14_2_2_Right_33 VGND VDPWR sky130_fd_sc_hd__tapvpwrvgnd_1
Xclkbuf_leaf_4_clk clkbuf_leaf_4_clk/A VGND VGND VDPWR VDPWR clkbuf_leaf_4_clk/X sky130_fd_sc_hd__clkbuf_2
X_1513_ _2156_/Q _1191_/B _2155_/Q VGND VGND VDPWR VDPWR _1513_/Y sky130_fd_sc_hd__o21ai_1
X_1444_ _2313_/A _1444_/B _1986_/A VGND VGND VDPWR VDPWR _1444_/Y sky130_fd_sc_hd__nor3_1
X_1375_ _1601_/A _1221_/A _1222_/Y _1399_/A VGND VGND VDPWR VDPWR _1375_/Y sky130_fd_sc_hd__a22oi_1
XFILLER_23_202 VGND VGND VDPWR VDPWR sky130_fd_sc_hd__fill_2
XTAP_TAPCELL_ROW_80_358 VGND VDPWR sky130_fd_sc_hd__tapvpwrvgnd_1
XFILLER_14_224 VGND VGND VDPWR VDPWR sky130_fd_sc_hd__decap_3
XFILLER_64_78 VGND VGND VDPWR VDPWR sky130_fd_sc_hd__decap_3
XTAP_TAPCELL_ROW_71_314 VGND VDPWR sky130_fd_sc_hd__tapvpwrvgnd_1
X_1091_ _1131_/C _1131_/D _1122_/C VGND VGND VDPWR VDPWR _1214_/B sky130_fd_sc_hd__nand3_1
X_1160_ _1874_/A1 _1480_/B _1332_/A1 VGND VGND VDPWR VDPWR _1168_/D sky130_fd_sc_hd__a21oi_1
Xu_sub.u_core.u_regfile.g_port\[1\].u_a u_sub.u_core.u_regfile.g_port\[1\].u_b/A0
+ u_sub.u_core.u_regfile.g_port\[1\].u_b/A1 u_sub.u_core.u_regfile.g_port\[1\].u_b/A2
+ u_sub.u_core.u_regfile.g_port\[1\].u_b/A3 wire88/X _1478_/X VGND VGND VDPWR VDPWR
+ u_sub.u_core.u_regfile.g_port\[1\].u_a/X tg_mux4_x1
X_1993_ hold57/A _2034_/S VGND VGND VDPWR VDPWR _1993_/Y sky130_fd_sc_hd__nand2b_1
XFILLER_62_1 VGND VGND VDPWR VDPWR sky130_fd_sc_hd__decap_3
X_1427_ _2133_/Q _2132_/Q VGND VGND VDPWR VDPWR _1795_/A sky130_fd_sc_hd__nand2_1
X_1358_ _2261_/Q _1465_/C _1357_/X VGND VGND VDPWR VDPWR _1358_/Y sky130_fd_sc_hd__a21oi_1
XFILLER_43_319 VGND VGND VDPWR VDPWR sky130_fd_sc_hd__fill_1
X_1289_ _1289_/A _1289_/B VGND VGND VDPWR VDPWR _1313_/A sky130_fd_sc_hd__nor2_1
Xclkload3 clkload3/A VGND VGND VDPWR VDPWR clkload3/Y sky130_fd_sc_hd__inv_8
Xwire118 hold25/X VGND VGND VDPWR VDPWR wire118/X sky130_fd_sc_hd__buf_6
XFILLER_46_168 VGND VGND VDPWR VDPWR sky130_fd_sc_hd__fill_2
XFILLER_61_149 VGND VGND VDPWR VDPWR sky130_fd_sc_hd__decap_3
Xdelaybuf_9_clk delaybuf_9_clk/A VGND VGND VDPWR VDPWR delaybuf_9_clk/X sky130_fd_sc_hd__clkbuf_2
XFILLER_41_6 VGND VGND VDPWR VDPWR sky130_fd_sc_hd__decap_3
XFILLER_6_231 VGND VGND VDPWR VDPWR sky130_fd_sc_hd__decap_3
Xu_sub.u_core.u_regfile.g_nibsel\[3\].g_nib\[3\].u_hi u_sub.u_core.u_regfile.g_word\[3\].g_byte\[2\].u_lat/Q3
+ u_sub.u_core.u_regfile.g_word\[3\].g_byte\[2\].u_lat/Q7 u_sub.u_core.u_regfile.g_word\[3\].g_byte\[3\].u_lat/Q3
+ u_sub.u_core.u_regfile.g_word\[3\].g_byte\[3\].u_lat/Q7 max_cap80/X max_cap4/X VGND
+ VGND VDPWR VDPWR u_sub.u_core.u_regfile.g_nibsel\[3\].g_nib\[3\].u_hi/X tg_mux4_x1
X_2261_ _2273_/CLK hold51/X VGND VGND VDPWR VDPWR _2261_/Q sky130_fd_sc_hd__dfxtp_1
X_2192_ clkload4/A _2192_/D VGND VGND VDPWR VDPWR _2192_/Q sky130_fd_sc_hd__dfxtp_1
X_1212_ _1175_/A _1914_/S VGND VGND VDPWR VDPWR _1212_/Y sky130_fd_sc_hd__nand2b_1
XFILLER_33_341 VGND VGND VDPWR VDPWR sky130_fd_sc_hd__decap_3
XFILLER_37_157 VGND VGND VDPWR VDPWR sky130_fd_sc_hd__fill_2
XTAP_TAPCELL_ROW_47_196 VGND VDPWR sky130_fd_sc_hd__tapvpwrvgnd_1
X_1074_ _1075_/A _1075_/C VGND VGND VDPWR VDPWR _1144_/C sky130_fd_sc_hd__nor2_1
X_1143_ _1570_/A _1143_/B VGND VGND VDPWR VDPWR _1592_/A sky130_fd_sc_hd__nor2_1
XFILLER_60_193 VGND VGND VDPWR VDPWR sky130_fd_sc_hd__fill_1
X_1976_ _2216_/Q _2191_/Q _1979_/B _2192_/Q VGND VGND VDPWR VDPWR _1982_/C sky130_fd_sc_hd__a22oi_1
Xhold26 hold26/A VGND VGND VDPWR VDPWR hold26/X sky130_fd_sc_hd__dlygate4sd3_1
Xhold37 hold37/A VGND VGND VDPWR VDPWR hold37/X sky130_fd_sc_hd__dlygate4sd3_1
Xhold48 hold48/A VGND VGND VDPWR VDPWR hold48/X sky130_fd_sc_hd__dlygate4sd3_1
Xhold59 hold59/A VGND VGND VDPWR VDPWR hold59/X sky130_fd_sc_hd__dlygate4sd3_1
XFILLER_51_171 VGND VGND VDPWR VDPWR sky130_fd_sc_hd__decap_3
XFILLER_61_35 VGND VGND VDPWR VDPWR sky130_fd_sc_hd__decap_3
XFILLER_3_234 VGND VGND VDPWR VDPWR sky130_fd_sc_hd__fill_2
XFILLER_61_79 VGND VGND VDPWR VDPWR sky130_fd_sc_hd__fill_1
XPHY_EDGE_ROW_60_Left_119 VGND VDPWR sky130_fd_sc_hd__tapvpwrvgnd_1
XFILLER_66_208 VGND VGND VDPWR VDPWR sky130_fd_sc_hd__fill_2
XTAP_TAPCELL_ROW_44_177 VGND VDPWR sky130_fd_sc_hd__tapvpwrvgnd_1
X_1830_ _1830_/A _1830_/B VGND VGND VDPWR VDPWR _1830_/Y sky130_fd_sc_hd__nor2_1
X_1761_ _2137_/Q wire71/X _2123_/A VGND VGND VDPWR VDPWR _1763_/A sky130_fd_sc_hd__o21ai_1
X_2313_ _2313_/A VGND VGND VDPWR VDPWR uio_out[4] sky130_fd_sc_hd__buf_2
X_1692_ _2191_/Q _1476_/B _1887_/B _2216_/Q VGND VGND VDPWR VDPWR _1693_/B sky130_fd_sc_hd__a22oi_1
X_2244_ _2257_/CLK hold55/X _2123_/A VGND VGND VDPWR VDPWR _2244_/Q sky130_fd_sc_hd__dfrtp_1
X_2175_ _2175_/CLK _2175_/D VGND VGND VDPWR VDPWR _2175_/Q sky130_fd_sc_hd__dfxtp_1
X_1126_ _1168_/B _1168_/C VGND VGND VDPWR VDPWR _1200_/B sky130_fd_sc_hd__or2_1
X_1057_ _1627_/A _1914_/S VGND VGND VDPWR VDPWR _1057_/Y sky130_fd_sc_hd__nand2_1
X_1959_ _2294_/D _1951_/Y _1803_/A VGND VGND VDPWR VDPWR _1960_/B sky130_fd_sc_hd__o21ai_1
XFILLER_71_211 VGND VGND VDPWR VDPWR sky130_fd_sc_hd__decap_3
XFILLER_71_233 VGND VGND VDPWR VDPWR sky130_fd_sc_hd__decap_3
XTAP_TAPCELL_ROW_58_247 VGND VDPWR sky130_fd_sc_hd__tapvpwrvgnd_1
XTAP_TAPCELL_ROW_66_291 VGND VDPWR sky130_fd_sc_hd__tapvpwrvgnd_1
XTAP_TAPCELL_ROW_49_203 VGND VDPWR sky130_fd_sc_hd__tapvpwrvgnd_1
Xclkbuf_0_clk clk VGND VGND VDPWR VDPWR clkbuf_0_clk/X sky130_fd_sc_hd__clkbuf_2
Xmax_cap80 _1623_/Y VGND VGND VDPWR VDPWR max_cap80/X sky130_fd_sc_hd__buf_6
Xmax_cap91 wire92/X VGND VGND VDPWR VDPWR max_cap91/X sky130_fd_sc_hd__clkbuf_8
X_1813_ _2229_/Q _1531_/B _1538_/A VGND VGND VDPWR VDPWR _1814_/C sky130_fd_sc_hd__o21ai_1
X_1744_ _1744_/A _1950_/A _1766_/B VGND VGND VDPWR VDPWR _1744_/Y sky130_fd_sc_hd__nand3_1
X_1675_ _2161_/Q wire85/X _1674_/Y VGND VGND VDPWR VDPWR _1675_/Y sky130_fd_sc_hd__a21oi_1
X_1109_ _1828_/A1 _1635_/B _1099_/Y _1108_/Y VGND VGND VDPWR VDPWR _1109_/Y sky130_fd_sc_hd__a22oi_1
X_2227_ clkload4/A _2227_/D VGND VGND VDPWR VDPWR _2315_/A sky130_fd_sc_hd__dfxtp_1
X_2158_ _2291_/CLK _2158_/D _2291_/D VGND VGND VDPWR VDPWR _2158_/Q sky130_fd_sc_hd__dfrtp_1
X_2089_ _2215_/Q _2088_/A _2088_/Y _2123_/A VGND VGND VDPWR VDPWR _2215_/D sky130_fd_sc_hd__o211a_1
XTAP_TAPCELL_ROW_63_272 VGND VDPWR sky130_fd_sc_hd__tapvpwrvgnd_1
XFILLER_67_78 VGND VGND VDPWR VDPWR sky130_fd_sc_hd__fill_2
XFILLER_44_233 VGND VGND VDPWR VDPWR sky130_fd_sc_hd__fill_1
Xclkbuf_0_u_sub.u_timer.g_cmp\[1\].g clkbuf_0_u_sub.u_timer.g_cmp\[1\].g/A VGND VGND
+ VDPWR VDPWR clkbuf_0_u_sub.u_timer.g_cmp\[1\].g/X sky130_fd_sc_hd__clkbuf_2
X_1460_ _2154_/Q _1460_/B VGND VGND VDPWR VDPWR _1606_/B sky130_fd_sc_hd__xnor2_1
X_1391_ _1266_/B _1388_/Y _1389_/Y _1390_/Y _1267_/B VGND VGND VDPWR VDPWR _1391_/X
+ sky130_fd_sc_hd__a2111o_1
XTAP_TAPCELL_ROW_77_342 VGND VDPWR sky130_fd_sc_hd__tapvpwrvgnd_1
X_2012_ _1416_/B _2044_/B _2011_/Y VGND VGND VDPWR VDPWR _2013_/B sky130_fd_sc_hd__a21oi_1
Xhold134 _2139_/Q VGND VGND VDPWR VDPWR hold25/A sky130_fd_sc_hd__dlygate4sd3_1
X_1727_ _2278_/Q _1727_/B VGND VGND VDPWR VDPWR _1729_/A sky130_fd_sc_hd__nor2_1
X_1658_ wire85/X _1658_/B VGND VGND VDPWR VDPWR _1658_/Y sky130_fd_sc_hd__nand2_1
X_1589_ _1591_/A _1605_/B _1609_/A _1610_/B VGND VGND VDPWR VDPWR _1589_/Y sky130_fd_sc_hd__nor4_1
XFILLER_41_225 VGND VGND VDPWR VDPWR sky130_fd_sc_hd__fill_2
XFILLER_40_280 VGND VGND VDPWR VDPWR sky130_fd_sc_hd__fill_1
Xclkbuf_0_u_sub.u_timer.u_cg_wd.gclk_o u_sub.u_timer.u_cg_wd.u_icg/GCLK VGND VGND
+ VDPWR VDPWR clkbuf_0_u_sub.u_timer.u_cg_wd.gclk_o/X sky130_fd_sc_hd__clkbuf_2
Xu_sub.u_core.u_regfile.g_word\[1\].g_byte\[0\].u_lat wire103/A wire102/X max_cap99/X
+ wire97/A wire95/A max_cap94/X wire92/X max_cap90/X u_sub.u_core.u_regfile.g_word\[1\].g_byte\[0\].u_lat/GATE
+ VGND VDPWR u_sub.u_core.u_regfile.g_word\[1\].g_byte\[0\].u_lat/Q0 u_sub.u_core.u_regfile.g_word\[1\].g_byte\[0\].u_lat/Q1
+ u_sub.u_core.u_regfile.g_word\[1\].g_byte\[0\].u_lat/Q2 u_sub.u_core.u_regfile.g_word\[1\].g_byte\[0\].u_lat/Q3
+ u_sub.u_core.u_regfile.g_word\[1\].g_byte\[0\].u_lat/Q4 u_sub.u_core.u_regfile.g_word\[1\].g_byte\[0\].u_lat/Q5
+ u_sub.u_core.u_regfile.g_word\[1\].g_byte\[0\].u_lat/Q6 u_sub.u_core.u_regfile.g_word\[1\].g_byte\[0\].u_lat/Q7
+ dlxtp8_x1
X_1512_ _1512_/A _1512_/B VGND VGND VDPWR VDPWR _1516_/B sky130_fd_sc_hd__nor2_1
XFILLER_67_166 VGND VGND VDPWR VDPWR sky130_fd_sc_hd__fill_1
X_1443_ _2206_/Q _2205_/Q VGND VGND VDPWR VDPWR _1986_/A sky130_fd_sc_hd__nor2_1
X_1374_ _1371_/Y _1372_/Y _1373_/Y VGND VGND VDPWR VDPWR _1379_/B sky130_fd_sc_hd__a21oi_1
XFILLER_67_177 VGND VGND VDPWR VDPWR sky130_fd_sc_hd__decap_3
XTAP_TAPCELL_ROW_80_359 VGND VDPWR sky130_fd_sc_hd__tapvpwrvgnd_1
XFILLER_46_339 VGND VGND VDPWR VDPWR sky130_fd_sc_hd__fill_1
XFILLER_58_122 VGND VGND VDPWR VDPWR sky130_fd_sc_hd__decap_3
XFILLER_58_166 VGND VGND VDPWR VDPWR sky130_fd_sc_hd__decap_3
XFILLER_58_199 VGND VGND VDPWR VDPWR sky130_fd_sc_hd__decap_3
XFILLER_14_203 VGND VGND VDPWR VDPWR sky130_fd_sc_hd__decap_3
XTAP_TAPCELL_ROW_71_315 VGND VDPWR sky130_fd_sc_hd__tapvpwrvgnd_1
XFILLER_49_133 VGND VGND VDPWR VDPWR sky130_fd_sc_hd__fill_1
XFILLER_49_177 VGND VGND VDPWR VDPWR sky130_fd_sc_hd__decap_3
X_1090_ _1131_/C _1131_/D _1122_/C VGND VGND VDPWR VDPWR _1124_/C sky130_fd_sc_hd__and3_1
Xclkload10 _2257_/CLK VGND VGND VDPWR VDPWR clkload10/Y sky130_fd_sc_hd__clkinv_1
Xu_sub.u_core.u_regfile.g_port\[1\].u_b u_sub.u_core.u_regfile.g_port\[1\].u_b/A0
+ u_sub.u_core.u_regfile.g_port\[1\].u_b/A1 u_sub.u_core.u_regfile.g_port\[1\].u_b/A2
+ u_sub.u_core.u_regfile.g_port\[1\].u_b/A3 _1400_/X _1479_/Y VGND VGND VDPWR VDPWR
+ u_sub.u_core.u_regfile.g_port\[1\].u_b/X tg_mux4_x1
X_1992_ _2034_/S hold46/A _1991_/Y VGND VGND VDPWR VDPWR _1992_/Y sky130_fd_sc_hd__o21ai_1
XFILLER_55_103 VGND VGND VDPWR VDPWR sky130_fd_sc_hd__fill_2
XPHY_EDGE_ROW_21_2_2_Left_10 VGND VDPWR sky130_fd_sc_hd__tapvpwrvgnd_1
Xclkbuf_1_0__f_u_sub.u_core.u_cg_wb_hi.gclk_o clkbuf_0_u_sub.u_core.u_cg_wb_hi.gclk_o/X
+ VGND VGND VDPWR VDPWR _2179_/CLK sky130_fd_sc_hd__clkbuf_2
X_1426_ _2116_/A _1691_/B _2116_/B VGND VGND VDPWR VDPWR _1477_/A sky130_fd_sc_hd__nand3_1
X_1357_ _2277_/Q _1393_/B _1277_/Y _1356_/Y VGND VGND VDPWR VDPWR _1357_/X sky130_fd_sc_hd__o211a_1
X_1288_ _1051_/A _1466_/A _1113_/Y _2244_/Q VGND VGND VDPWR VDPWR _1289_/B sky130_fd_sc_hd__o22ai_1
Xu_sub.u_core.u_regfile.g_nibsel\[4\].g_nib\[1\].u_hi u_sub.u_core.u_regfile.g_word\[4\].g_byte\[2\].u_lat/Q1
+ u_sub.u_core.u_regfile.g_word\[4\].g_byte\[2\].u_lat/Q5 u_sub.u_core.u_regfile.g_word\[4\].g_byte\[3\].u_lat/Q1
+ u_sub.u_core.u_regfile.g_word\[4\].g_byte\[3\].u_lat/Q5 max_cap6/X max_cap79/X VGND
+ VGND VDPWR VDPWR u_sub.u_core.u_regfile.g_nibsel\[4\].g_nib\[1\].u_hi/X tg_mux4_x1
Xclkload4 clkload4/A VGND VGND VDPWR VDPWR clkload4/Y sky130_fd_sc_hd__bufinv_16
Xwire108 _1070_/Y VGND VGND VDPWR VDPWR _1236_/A sky130_fd_sc_hd__clkbuf_2
XFILLER_59_35 VGND VGND VDPWR VDPWR sky130_fd_sc_hd__decap_3
XFILLER_69_217 VGND VGND VDPWR VDPWR sky130_fd_sc_hd__decap_3
XFILLER_37_125 VGND VGND VDPWR VDPWR sky130_fd_sc_hd__decap_3
X_2260_ _2273_/CLK hold52/X VGND VGND VDPWR VDPWR _2260_/Q sky130_fd_sc_hd__dfxtp_1
X_2191_ clkload4/A _2191_/D VGND VGND VDPWR VDPWR _2191_/Q sky130_fd_sc_hd__dfxtp_1
X_1211_ _1211_/A _1211_/B VGND VGND VDPWR VDPWR _1211_/Y sky130_fd_sc_hd__nand2_1
X_1142_ _1144_/A _1144_/C VGND VGND VDPWR VDPWR _1143_/B sky130_fd_sc_hd__nand2_1
XFILLER_33_331 VGND VGND VDPWR VDPWR sky130_fd_sc_hd__decap_3
XFILLER_45_191 VGND VGND VDPWR VDPWR sky130_fd_sc_hd__decap_3
XFILLER_60_172 VGND VGND VDPWR VDPWR sky130_fd_sc_hd__fill_2
X_1073_ _1118_/A _1168_/B _1237_/B VGND VGND VDPWR VDPWR _1172_/A sky130_fd_sc_hd__or3_1
X_1975_ _2216_/Q _2191_/Q VGND VGND VDPWR VDPWR _1979_/C sky130_fd_sc_hd__nand2_1
XPHY_EDGE_ROW_49_Right_68 VGND VDPWR sky130_fd_sc_hd__tapvpwrvgnd_1
Xhold27 hold27/A VGND VGND VDPWR VDPWR hold27/X sky130_fd_sc_hd__dlygate4sd3_1
Xhold38 hold38/A VGND VGND VDPWR VDPWR hold38/X sky130_fd_sc_hd__dlygate4sd3_1
X_1409_ _1408_/A _1682_/A _1541_/C _1829_/A VGND VGND VDPWR VDPWR _1855_/B sky130_fd_sc_hd__nand4b_1
XFILLER_43_106 VGND VGND VDPWR VDPWR sky130_fd_sc_hd__decap_3
XFILLER_43_128 VGND VGND VDPWR VDPWR sky130_fd_sc_hd__decap_3
XPHY_EDGE_ROW_22_2_2_Left_11 VGND VDPWR sky130_fd_sc_hd__tapvpwrvgnd_1
XPHY_EDGE_ROW_58_Right_77 VGND VDPWR sky130_fd_sc_hd__tapvpwrvgnd_1
Xhold49 hold49/A VGND VGND VDPWR VDPWR hold49/X sky130_fd_sc_hd__dlygate4sd3_1
XFILLER_61_47 VGND VGND VDPWR VDPWR sky130_fd_sc_hd__decap_3
XPHY_EDGE_ROW_67_Right_86 VGND VDPWR sky130_fd_sc_hd__tapvpwrvgnd_1
XPHY_EDGE_ROW_76_Right_95 VGND VDPWR sky130_fd_sc_hd__tapvpwrvgnd_1
Xclkbuf_regs_0_clk delaybuf_21_clk/X VGND VGND VDPWR VDPWR clkbuf_regs_0_clk/X sky130_fd_sc_hd__clkbuf_2
Xu_sub.u_core.u_regfile.g_port\[0\].u_a u_sub.u_core.u_regfile.g_port\[0\].u_b/A0
+ u_sub.u_core.u_regfile.g_port\[0\].u_b/A1 u_sub.u_core.u_regfile.g_port\[0\].u_b/A2
+ u_sub.u_core.u_regfile.g_port\[0\].u_b/A3 wire88/X _1478_/X VGND VGND VDPWR VDPWR
+ u_sub.u_core.u_regfile.g_port\[0\].u_a/X tg_mux4_x1
XTAP_TAPCELL_ROW_44_178 VGND VDPWR sky130_fd_sc_hd__tapvpwrvgnd_1
X_1760_ _1760_/A _1760_/B VGND VGND VDPWR VDPWR _2136_/D sky130_fd_sc_hd__nor2_1
X_1691_ _1691_/A _1691_/B _1990_/A VGND VGND VDPWR VDPWR _2116_/C sky130_fd_sc_hd__nor3_1
X_2312_ _2312_/A VGND VGND VDPWR VDPWR uio_oe[5] sky130_fd_sc_hd__buf_2
X_2243_ _2258_/CLK hold61/X hold24/X VGND VGND VDPWR VDPWR _2243_/Q sky130_fd_sc_hd__dfrtp_1
X_2174_ _2174_/CLK _2174_/D VGND VGND VDPWR VDPWR _2174_/Q sky130_fd_sc_hd__dfxtp_1
X_1125_ _1168_/B _1168_/C VGND VGND VDPWR VDPWR _1221_/A sky130_fd_sc_hd__nor2_1
XFILLER_18_191 VGND VGND VDPWR VDPWR sky130_fd_sc_hd__decap_3
XFILLER_40_109 VGND VGND VDPWR VDPWR sky130_fd_sc_hd__decap_3
X_1056_ _2155_/Q _1614_/A VGND VGND VDPWR VDPWR _1376_/B sky130_fd_sc_hd__nor2_1
X_1958_ _2189_/Q _1961_/B VGND VGND VDPWR VDPWR _1960_/A sky130_fd_sc_hd__nor2_1
X_1889_ _1889_/A1 wire81/X _1914_/S VGND VGND VDPWR VDPWR _1889_/Y sky130_fd_sc_hd__a21oi_1
XFILLER_56_231 VGND VGND VDPWR VDPWR sky130_fd_sc_hd__decap_3
XTAP_TAPCELL_ROW_58_248 VGND VDPWR sky130_fd_sc_hd__tapvpwrvgnd_1
XFILLER_71_201 VGND VGND VDPWR VDPWR sky130_fd_sc_hd__decap_3
XPHY_EDGE_ROW_23_2_2_Left_12 VGND VDPWR sky130_fd_sc_hd__tapvpwrvgnd_1
XFILLER_24_194 VGND VGND VDPWR VDPWR sky130_fd_sc_hd__decap_3
XFILLER_62_212 VGND VGND VDPWR VDPWR sky130_fd_sc_hd__fill_1
XTAP_TAPCELL_ROW_49_204 VGND VDPWR sky130_fd_sc_hd__tapvpwrvgnd_1
XFILLER_15_194 VGND VGND VDPWR VDPWR sky130_fd_sc_hd__decap_3
XFILLER_30_197 VGND VGND VDPWR VDPWR sky130_fd_sc_hd__fill_1
Xu_sub.u_core.u_regfile.g_nibsel\[1\].g_nib\[0\].u_m2 u_sub.u_core.u_regfile.g_nibsel\[1\].g_nib\[0\].u_lo/X
+ u_sub.u_core.u_regfile.g_nibsel\[1\].g_nib\[0\].u_hi/X max_cap1/X VGND VGND VDPWR
+ VDPWR u_sub.u_core.u_regfile.g_port\[0\].u_b/A0 sky130_fd_sc_hd__mux2_1
X_1812_ _1814_/A _1814_/B VGND VGND VDPWR VDPWR _1824_/B sky130_fd_sc_hd__nand2_1
X_1743_ _1750_/B _1743_/B VGND VGND VDPWR VDPWR _1766_/B sky130_fd_sc_hd__nand2_1
X_1674_ wire85/X _1674_/B VGND VGND VDPWR VDPWR _1674_/Y sky130_fd_sc_hd__nor2_1
X_2226_ clkload8/A _2226_/D VGND VGND VDPWR VDPWR _2226_/Q sky130_fd_sc_hd__dfxtp_1
X_1108_ _1108_/A _1108_/B VGND VGND VDPWR VDPWR _1108_/Y sky130_fd_sc_hd__nand2_1
X_2157_ _2291_/CLK _2157_/D _2291_/D VGND VGND VDPWR VDPWR _2157_/Q sky130_fd_sc_hd__dfrtp_1
X_2088_ _2088_/A _2090_/B VGND VGND VDPWR VDPWR _2088_/Y sky130_fd_sc_hd__nand2_1
XTAP_TAPCELL_ROW_63_273 VGND VDPWR sky130_fd_sc_hd__tapvpwrvgnd_1
XFILLER_67_13 VGND VGND VDPWR VDPWR sky130_fd_sc_hd__decap_3
XFILLER_29_220 VGND VGND VDPWR VDPWR sky130_fd_sc_hd__fill_1
XPHY_EDGE_ROW_24_2_2_Left_13 VGND VDPWR sky130_fd_sc_hd__tapvpwrvgnd_1
X_1390_ _1365_/Y _1389_/C _1270_/Y VGND VGND VDPWR VDPWR _1390_/Y sky130_fd_sc_hd__a21oi_1
XTAP_TAPCELL_ROW_77_343 VGND VDPWR sky130_fd_sc_hd__tapvpwrvgnd_1
X_2011_ _2044_/B _2011_/B VGND VGND VDPWR VDPWR _2011_/Y sky130_fd_sc_hd__nor2_1
Xhold135 _2147_/Q VGND VGND VDPWR VDPWR _1796_/A sky130_fd_sc_hd__dlygate4sd3_1
X_1726_ _1726_/A _1726_/B VGND VGND VDPWR VDPWR _2289_/D sky130_fd_sc_hd__nor2_1
X_1657_ _1856_/A1 _1654_/Y _1655_/X VGND VGND VDPWR VDPWR _1658_/B sky130_fd_sc_hd__a21oi_1
X_1588_ _1609_/A _1610_/B VGND VGND VDPWR VDPWR _1600_/B sky130_fd_sc_hd__nor2_1
X_2209_ clkload8/A _2209_/D VGND VGND VDPWR VDPWR _2209_/Q sky130_fd_sc_hd__dfxtp_1
XFILLER_26_234 VGND VGND VDPWR VDPWR sky130_fd_sc_hd__fill_2
XFILLER_41_215 VGND VGND VDPWR VDPWR sky130_fd_sc_hd__fill_1
Xu_sub.u_core.u_regfile.g_word\[4\].g_byte\[2\].u_lat wire103/A wire102/X max_cap99/X
+ wire97/A wire95/A max_cap94/X wire92/X max_cap90/X u_sub.u_core.u_regfile.g_word\[4\].g_byte\[2\].u_lat/GATE
+ VGND VDPWR u_sub.u_core.u_regfile.g_word\[4\].g_byte\[2\].u_lat/Q0 u_sub.u_core.u_regfile.g_word\[4\].g_byte\[2\].u_lat/Q1
+ u_sub.u_core.u_regfile.g_word\[4\].g_byte\[2\].u_lat/Q2 u_sub.u_core.u_regfile.g_word\[4\].g_byte\[2\].u_lat/Q3
+ u_sub.u_core.u_regfile.g_word\[4\].g_byte\[2\].u_lat/Q4 u_sub.u_core.u_regfile.g_word\[4\].g_byte\[2\].u_lat/Q5
+ u_sub.u_core.u_regfile.g_word\[4\].g_byte\[2\].u_lat/Q6 u_sub.u_core.u_regfile.g_word\[4\].g_byte\[2\].u_lat/Q7
+ dlxtp8_x1
XPHY_EDGE_ROW_25_2_2_Left_14 VGND VDPWR sky130_fd_sc_hd__tapvpwrvgnd_1
XFILLER_32_226 VGND VGND VDPWR VDPWR sky130_fd_sc_hd__fill_1
XFILLER_40_292 VGND VGND VDPWR VDPWR sky130_fd_sc_hd__fill_2
XFILLER_71_7 VGND VGND VDPWR VDPWR sky130_fd_sc_hd__decap_3
Xclkbuf_0_u_sub.u_core.u_cg_wb_hi.gclk_o u_sub.u_core.u_cg_wb_hi.u_icg/GCLK VGND VGND
+ VDPWR VDPWR clkbuf_0_u_sub.u_core.u_cg_wb_hi.gclk_o/X sky130_fd_sc_hd__clkbuf_2
X_1511_ _2231_/Q _1504_/Y _1510_/Y _1502_/Y VGND VGND VDPWR VDPWR _1512_/B sky130_fd_sc_hd__o211ai_1
X_1442_ _2207_/Q _2206_/Q _2204_/Q VGND VGND VDPWR VDPWR _1444_/B sky130_fd_sc_hd__nor3_1
XFILLER_55_307 VGND VGND VDPWR VDPWR sky130_fd_sc_hd__fill_2
X_1373_ _1179_/B _1211_/A _1360_/B VGND VGND VDPWR VDPWR _1373_/Y sky130_fd_sc_hd__o21ai_1
X_1709_ _2229_/Q _2233_/Q _2160_/Q _2176_/D VGND VGND VDPWR VDPWR _2172_/D sky130_fd_sc_hd__a31o_1
XFILLER_58_178 VGND VGND VDPWR VDPWR sky130_fd_sc_hd__fill_1
XFILLER_64_69 VGND VGND VDPWR VDPWR sky130_fd_sc_hd__decap_3
XFILLER_14_215 VGND VGND VDPWR VDPWR sky130_fd_sc_hd__fill_2
XTAP_TAPCELL_ROW_71_316 VGND VDPWR sky130_fd_sc_hd__tapvpwrvgnd_1
Xdelaybuf_19_clk clk VGND VGND VDPWR VDPWR delaybuf_20_clk/A sky130_fd_sc_hd__clkbuf_2
XFILLER_37_307 VGND VGND VDPWR VDPWR sky130_fd_sc_hd__decap_3
XFILLER_38_81 VGND VGND VDPWR VDPWR sky130_fd_sc_hd__decap_3
XFILLER_49_156 VGND VGND VDPWR VDPWR sky130_fd_sc_hd__decap_3
XPHY_EDGE_ROW_26_2_2_Left_15 VGND VDPWR sky130_fd_sc_hd__tapvpwrvgnd_1
XTAP_TAPCELL_ROW_11_2_2_140 VGND VDPWR sky130_fd_sc_hd__tapvpwrvgnd_1
X_1991_ hold53/A _2034_/S VGND VGND VDPWR VDPWR _1991_/Y sky130_fd_sc_hd__nand2b_1
X_1425_ _1690_/A _2112_/A VGND VGND VDPWR VDPWR wire81/A sky130_fd_sc_hd__nor2_1
X_1356_ _1393_/B _1902_/A VGND VGND VDPWR VDPWR _1356_/Y sky130_fd_sc_hd__nand2_1
X_1287_ _1051_/A _1635_/B _1099_/Y _1286_/Y _1364_/A VGND VGND VDPWR VDPWR _1289_/A
+ sky130_fd_sc_hd__a221oi_1
Xclkload5 clkload5/A VGND VGND VDPWR VDPWR clkload5/Y sky130_fd_sc_hd__inv_6
Xwire109 _1069_/Y VGND VGND VDPWR VDPWR _1173_/A sky130_fd_sc_hd__buf_1
XFILLER_42_321 VGND VGND VDPWR VDPWR sky130_fd_sc_hd__fill_1
Xu_sub.u_core.u_regfile.g_ir\[3\].u_cg.u_icg clkload0/A _1610_/Y VGND VGND VDPWR VDPWR
+ u_sub.u_core.u_regfile.g_ir\[3\].u_lat/GATE sky130_fd_sc_hd__dlclkp_1
XFILLER_69_229 VGND VGND VDPWR VDPWR sky130_fd_sc_hd__fill_2
X_1072_ _1137_/A _1182_/A VGND VGND VDPWR VDPWR _1237_/B sky130_fd_sc_hd__nand2_1
Xu_sub.u_core.u_regfile.g_nibsel\[3\].g_nib\[3\].u_lo u_sub.u_core.u_regfile.g_word\[3\].g_byte\[0\].u_lat/Q3
+ u_sub.u_core.u_regfile.g_word\[3\].g_byte\[0\].u_lat/Q7 u_sub.u_core.u_regfile.g_word\[3\].g_byte\[1\].u_lat/Q3
+ u_sub.u_core.u_regfile.g_word\[3\].g_byte\[1\].u_lat/Q7 max_cap80/X max_cap4/X VGND
+ VGND VDPWR VDPWR u_sub.u_core.u_regfile.g_nibsel\[3\].g_nib\[3\].u_lo/X tg_mux4_x1
X_2190_ clkload5/A _2190_/D VGND VGND VDPWR VDPWR _2190_/Q sky130_fd_sc_hd__dfxtp_1
X_1210_ _1210_/A _1367_/C VGND VGND VDPWR VDPWR _1210_/Y sky130_fd_sc_hd__nor2_1
X_1141_ _1141_/A _1141_/B _1162_/A _1141_/D VGND VGND VDPWR VDPWR _1449_/A sky130_fd_sc_hd__nor4_1
XPHY_EDGE_ROW_27_2_2_Left_16 VGND VDPWR sky130_fd_sc_hd__tapvpwrvgnd_1
X_1974_ _1974_/A _1974_/B VGND VGND VDPWR VDPWR _2193_/D sky130_fd_sc_hd__nor2_1
XPHY_EDGE_ROW_26_2_2_Right_45 VGND VDPWR sky130_fd_sc_hd__tapvpwrvgnd_1
XFILLER_68_262 VGND VGND VDPWR VDPWR sky130_fd_sc_hd__decap_3
XFILLER_68_273 VGND VGND VDPWR VDPWR sky130_fd_sc_hd__fill_2
Xhold28 hold28/A VGND VGND VDPWR VDPWR hold28/X sky130_fd_sc_hd__dlygate4sd3_1
Xhold39 hold39/A VGND VGND VDPWR VDPWR hold39/X sky130_fd_sc_hd__dlygate4sd3_1
Xu_fpga VGND VDPWR _2127_/D _2128_/D _2187_/Q _2188_/Q wire126/X wire125/X wire124/X
+ wire123/X _2140_/Q _2141_/Q _2142_/Q _2143_/Q _2144_/Q _2145_/Q _2151_/Q u_fpga/clk
+ ui_in[1] ui_in[2] uio_in[6] uio_in[7] uio_oe[6] uio_oe[7] wire15/A wire13/A uo_out[1]
+ uo_out[2] wire118/X island
X_1408_ _1408_/A _1643_/C VGND VGND VDPWR VDPWR _1683_/A sky130_fd_sc_hd__nor2_1
XFILLER_45_38 VGND VGND VDPWR VDPWR sky130_fd_sc_hd__fill_2
X_1339_ _1914_/S _1339_/B VGND VGND VDPWR VDPWR _1339_/Y sky130_fd_sc_hd__nor2_1
Xu_sub.u_core.u_regfile.g_nibsel\[1\].g_nib\[2\].u_hi u_sub.u_core.u_regfile.g_word\[1\].g_byte\[2\].u_lat/Q2
+ u_sub.u_core.u_regfile.g_word\[1\].g_byte\[2\].u_lat/Q6 u_sub.u_core.u_regfile.g_word\[1\].g_byte\[3\].u_lat/Q2
+ u_sub.u_core.u_regfile.g_word\[1\].g_byte\[3\].u_lat/Q6 max_cap6/X max_cap3/X VGND
+ VGND VDPWR VDPWR u_sub.u_core.u_regfile.g_nibsel\[1\].g_nib\[2\].u_hi/X tg_mux4_x1
XFILLER_3_214 VGND VGND VDPWR VDPWR sky130_fd_sc_hd__decap_3
XFILLER_59_251 VGND VGND VDPWR VDPWR sky130_fd_sc_hd__fill_1
Xu_sub.u_core.u_regfile.g_port\[0\].u_b u_sub.u_core.u_regfile.g_port\[0\].u_b/A0
+ u_sub.u_core.u_regfile.g_port\[0\].u_b/A1 u_sub.u_core.u_regfile.g_port\[0\].u_b/A2
+ u_sub.u_core.u_regfile.g_port\[0\].u_b/A3 _1400_/X _1479_/Y VGND VGND VDPWR VDPWR
+ u_sub.u_core.u_regfile.g_port\[0\].u_b/X tg_mux4_x1
XFILLER_42_140 VGND VGND VDPWR VDPWR sky130_fd_sc_hd__decap_3
XFILLER_42_162 VGND VGND VDPWR VDPWR sky130_fd_sc_hd__fill_2
XTAP_TAPCELL_ROW_44_179 VGND VDPWR sky130_fd_sc_hd__tapvpwrvgnd_1
X_1690_ _1690_/A _1990_/A _2036_/A VGND VGND VDPWR VDPWR _1965_/C sky130_fd_sc_hd__nand3_1
XFILLER_32_4 VGND VGND VDPWR VDPWR sky130_fd_sc_hd__decap_3
X_2311_ _2312_/A VGND VGND VDPWR VDPWR uio_oe[4] sky130_fd_sc_hd__buf_2
X_2242_ clkload5/A _2242_/D _1803_/A VGND VGND VDPWR VDPWR _2320_/A sky130_fd_sc_hd__dfrtp_1
X_1055_ _1848_/B _2234_/Q VGND VGND VDPWR VDPWR _1728_/B sky130_fd_sc_hd__nand2_1
Xclkbuf_0_u_sub.u_core.addr_gclk u_sub.u_core.u_cg_addr.u_icg/GCLK VGND VGND VDPWR
+ VDPWR clkbuf_0_u_sub.u_core.addr_gclk/X sky130_fd_sc_hd__clkbuf_2
X_2173_ _2174_/CLK _2173_/D VGND VGND VDPWR VDPWR _2173_/Q sky130_fd_sc_hd__dfxtp_1
X_1124_ _1214_/A _1236_/B _1124_/C VGND VGND VDPWR VDPWR _1211_/A sky130_fd_sc_hd__nand3_1
XPHY_EDGE_ROW_28_2_2_Left_17 VGND VDPWR sky130_fd_sc_hd__tapvpwrvgnd_1
X_1957_ _1957_/A _1957_/B VGND VGND VDPWR VDPWR _2188_/D sky130_fd_sc_hd__nor2_1
X_1888_ _1621_/B _1886_/Y _1887_/Y VGND VGND VDPWR VDPWR _1888_/Y sky130_fd_sc_hd__o21ai_1
XFILLER_56_221 VGND VGND VDPWR VDPWR sky130_fd_sc_hd__fill_1
XFILLER_56_265 VGND VGND VDPWR VDPWR sky130_fd_sc_hd__decap_3
XTAP_TAPCELL_ROW_58_249 VGND VDPWR sky130_fd_sc_hd__tapvpwrvgnd_1
XFILLER_71_224 VGND VGND VDPWR VDPWR sky130_fd_sc_hd__decap_3
XTAP_TAPCELL_ROW_49_205 VGND VDPWR sky130_fd_sc_hd__tapvpwrvgnd_1
XFILLER_62_202 VGND VGND VDPWR VDPWR sky130_fd_sc_hd__fill_2
Xmax_cap82 _1708_/B VGND VGND VDPWR VDPWR _2125_/A sky130_fd_sc_hd__clkbuf_2
Xmax_cap93 max_cap94/X VGND VGND VDPWR VDPWR max_cap93/X sky130_fd_sc_hd__buf_6
X_1811_ _2230_/Q _1811_/B _1855_/C VGND VGND VDPWR VDPWR _1814_/B sky130_fd_sc_hd__nand3_1
Xu_sub.u_core.u_regfile.g_word\[3\].g_byte\[1\].u_cg.u_icg delaybuf_1_clk/X _1599_/X
+ VGND VGND VDPWR VDPWR u_sub.u_core.u_regfile.g_word\[3\].g_byte\[1\].u_lat/GATE
+ sky130_fd_sc_hd__dlclkp_1
X_1742_ _2181_/Q _1915_/B _1743_/B VGND VGND VDPWR VDPWR _1950_/A sky130_fd_sc_hd__nand3b_1
X_1673_ _1828_/A1 _1654_/Y _1655_/X VGND VGND VDPWR VDPWR _1674_/B sky130_fd_sc_hd__a21oi_1
XFILLER_38_254 VGND VGND VDPWR VDPWR sky130_fd_sc_hd__decap_3
X_2225_ clkload8/A _2225_/D VGND VGND VDPWR VDPWR _2225_/Q sky130_fd_sc_hd__dfxtp_1
XFILLER_38_265 VGND VGND VDPWR VDPWR sky130_fd_sc_hd__decap_3
XTAP_TAPCELL_ROW_63_274 VGND VDPWR sky130_fd_sc_hd__tapvpwrvgnd_1
X_1107_ hold57/A _1360_/B _1322_/B _2243_/Q hold61/A _1376_/B VGND VGND VDPWR VDPWR
+ _1108_/B sky130_fd_sc_hd__a222oi_1
Xu_sub.u_core.u_regfile.g_word\[1\].g_byte\[3\].u_cg.u_icg clkbuf_leaf_3_clk/X _1591_/Y
+ VGND VGND VDPWR VDPWR u_sub.u_core.u_regfile.g_word\[1\].g_byte\[3\].u_lat/GATE
+ sky130_fd_sc_hd__dlclkp_1
X_2156_ clkload7/A _2156_/D _2291_/D VGND VGND VDPWR VDPWR _2156_/Q sky130_fd_sc_hd__dfrtp_1
X_2087_ _2215_/Q _2087_/B VGND VGND VDPWR VDPWR _2090_/B sky130_fd_sc_hd__xor2_1
XPHY_EDGE_ROW_29_2_2_Left_18 VGND VDPWR sky130_fd_sc_hd__tapvpwrvgnd_1
XFILLER_44_202 VGND VGND VDPWR VDPWR sky130_fd_sc_hd__fill_2
XFILLER_67_58 VGND VGND VDPWR VDPWR sky130_fd_sc_hd__decap_3
XPHY_EDGE_ROW_48_Left_107 VGND VDPWR sky130_fd_sc_hd__tapvpwrvgnd_1
XPHY_EDGE_ROW_57_Left_116 VGND VDPWR sky130_fd_sc_hd__tapvpwrvgnd_1
XTAP_TAPCELL_ROW_54_230 VGND VDPWR sky130_fd_sc_hd__tapvpwrvgnd_1
XFILLER_32_61 VGND VGND VDPWR VDPWR sky130_fd_sc_hd__decap_3
XFILLER_32_72 VGND VGND VDPWR VDPWR sky130_fd_sc_hd__fill_1
XFILLER_32_83 VGND VGND VDPWR VDPWR sky130_fd_sc_hd__decap_3
XPHY_EDGE_ROW_66_Left_125 VGND VDPWR sky130_fd_sc_hd__tapvpwrvgnd_1
XTAP_TAPCELL_ROW_77_344 VGND VDPWR sky130_fd_sc_hd__tapvpwrvgnd_1
X_2010_ _2034_/S hold63/A _2009_/Y VGND VGND VDPWR VDPWR _2011_/B sky130_fd_sc_hd__a21oi_1
XFILLER_35_202 VGND VGND VDPWR VDPWR sky130_fd_sc_hd__decap_3
XPHY_EDGE_ROW_75_Left_134 VGND VDPWR sky130_fd_sc_hd__tapvpwrvgnd_1
X_1725_ _2245_/Q _1728_/B VGND VGND VDPWR VDPWR _1726_/B sky130_fd_sc_hd__nor2_1
Xclkbuf_leaf_7_clk delaybuf_15_clk/A VGND VGND VDPWR VDPWR u_adc/clk sky130_fd_sc_hd__clkbuf_2
Xhold136 _2129_/Q VGND VGND VDPWR VDPWR _1935_/A sky130_fd_sc_hd__dlygate4sd3_1
X_1656_ _2170_/Q _1656_/B _1656_/C VGND VGND VDPWR VDPWR _1656_/Y sky130_fd_sc_hd__nand3_1
X_1587_ _1591_/A _1605_/B _1608_/A VGND VGND VDPWR VDPWR _1587_/Y sky130_fd_sc_hd__nor3_1
XTAP_TAPCELL_ROW_68_300 VGND VDPWR sky130_fd_sc_hd__tapvpwrvgnd_1
Xclkbuf_1_0__f_u_sub.u_core.u_cg_wb_lo.gclk_o clkbuf_0_u_sub.u_core.u_cg_wb_lo.gclk_o/X
+ VGND VGND VDPWR VDPWR _2175_/CLK sky130_fd_sc_hd__clkbuf_2
X_2208_ clkload8/A _2208_/D VGND VGND VDPWR VDPWR _2208_/Q sky130_fd_sc_hd__dfxtp_1
X_2139_ clkload6/A _2139_/D VGND VGND VDPWR VDPWR _2139_/Q sky130_fd_sc_hd__dfxtp_1
X_1510_ _2157_/Q _1680_/A _2156_/Q VGND VGND VDPWR VDPWR _1510_/Y sky130_fd_sc_hd__o21ai_1
X_1441_ _2207_/Q _2042_/D VGND VGND VDPWR VDPWR _1486_/C sky130_fd_sc_hd__nand2_1
X_1372_ _1570_/A _1128_/B _1210_/A VGND VGND VDPWR VDPWR _1372_/Y sky130_fd_sc_hd__a21oi_1
X_1708_ _1708_/A _1708_/B _1708_/C VGND VGND VDPWR VDPWR _2176_/D sky130_fd_sc_hd__nor3_1
XFILLER_58_157 VGND VGND VDPWR VDPWR sky130_fd_sc_hd__fill_1
X_1639_ _1639_/A _1638_/Y VGND VGND VDPWR VDPWR _1640_/B sky130_fd_sc_hd__nor2b_1
XFILLER_14_227 VGND VGND VDPWR VDPWR sky130_fd_sc_hd__decap_3
XFILLER_66_190 VGND VGND VDPWR VDPWR sky130_fd_sc_hd__decap_3
XFILLER_49_124 VGND VGND VDPWR VDPWR sky130_fd_sc_hd__decap_3
XFILLER_64_116 VGND VGND VDPWR VDPWR sky130_fd_sc_hd__fill_1
X_1990_ _1990_/A _1990_/B VGND VGND VDPWR VDPWR _1990_/Y sky130_fd_sc_hd__nand2_1
XFILLER_62_4 VGND VGND VDPWR VDPWR sky130_fd_sc_hd__decap_3
X_1424_ _1424_/A _2116_/B VGND VGND VDPWR VDPWR _2112_/A sky130_fd_sc_hd__nand2_1
X_1355_ _1267_/B _1870_/B _1354_/Y VGND VGND VDPWR VDPWR _1902_/A sky130_fd_sc_hd__a21oi_1
X_1286_ _1286_/A _1286_/B VGND VGND VDPWR VDPWR _1286_/Y sky130_fd_sc_hd__nor2_1
Xclkload6 clkload6/A VGND VGND VDPWR VDPWR clkload6/Y sky130_fd_sc_hd__clkinv_8
Xu_sub.u_core.u_regfile.g_nibsel\[4\].g_nib\[1\].u_lo u_sub.u_core.u_regfile.g_word\[4\].g_byte\[0\].u_lat/Q1
+ u_sub.u_core.u_regfile.g_word\[4\].g_byte\[0\].u_lat/Q5 u_sub.u_core.u_regfile.g_word\[4\].g_byte\[1\].u_lat/Q1
+ u_sub.u_core.u_regfile.g_word\[4\].g_byte\[1\].u_lat/Q5 max_cap6/X max_cap3/X VGND
+ VGND VDPWR VDPWR u_sub.u_core.u_regfile.g_nibsel\[4\].g_nib\[1\].u_lo/X tg_mux4_x1
Xu_sub.u_core.u_regfile.g_port\[2\].u_za u_sub.u_core.u_regfile.g_port\[2\].u_a/X
+ _1189_/C VGND VGND VDPWR VDPWR _1660_/A1 sky130_fd_sc_hd__and2_1
XFILLER_46_105 VGND VGND VDPWR VDPWR sky130_fd_sc_hd__fill_2
XFILLER_54_160 VGND VGND VDPWR VDPWR sky130_fd_sc_hd__fill_2
XFILLER_6_234 VGND VGND VDPWR VDPWR sky130_fd_sc_hd__fill_2
XFILLER_40_83 VGND VGND VDPWR VDPWR sky130_fd_sc_hd__fill_2
Xu_sub.u_core.u_regfile.g_nibsel\[2\].g_nib\[0\].u_hi u_sub.u_core.u_regfile.g_word\[2\].g_byte\[2\].u_lat/Q0
+ u_sub.u_core.u_regfile.g_word\[2\].g_byte\[2\].u_lat/Q4 u_sub.u_core.u_regfile.g_word\[2\].g_byte\[3\].u_lat/Q0
+ u_sub.u_core.u_regfile.g_word\[2\].g_byte\[3\].u_lat/Q4 max_cap7/X max_cap79/X VGND
+ VGND VDPWR VDPWR u_sub.u_core.u_regfile.g_nibsel\[2\].g_nib\[0\].u_hi/X tg_mux4_x1
XFILLER_45_171 VGND VGND VDPWR VDPWR sky130_fd_sc_hd__fill_2
XFILLER_52_119 VGND VGND VDPWR VDPWR sky130_fd_sc_hd__decap_3
X_1071_ _1122_/C _1214_/A _1131_/C _1131_/D VGND VGND VDPWR VDPWR _1168_/B sky130_fd_sc_hd__nand4bb_1
X_1140_ _1276_/A _1408_/A VGND VGND VDPWR VDPWR _1539_/A sky130_fd_sc_hd__nand2_1
XFILLER_33_344 VGND VGND VDPWR VDPWR sky130_fd_sc_hd__fill_1
X_1973_ _2294_/D _1965_/X _1803_/A VGND VGND VDPWR VDPWR _1974_/B sky130_fd_sc_hd__o21ai_1
XFILLER_68_296 VGND VGND VDPWR VDPWR sky130_fd_sc_hd__fill_2
Xhold29 hold29/A VGND VGND VDPWR VDPWR hold29/X sky130_fd_sc_hd__dlygate4sd3_1
X_1407_ _2156_/Q _1079_/A _1191_/B _1257_/B VGND VGND VDPWR VDPWR _1682_/A sky130_fd_sc_hd__o211ai_1
X_1338_ _1210_/Y _1336_/Y _1337_/Y _1295_/Y VGND VGND VDPWR VDPWR _1338_/Y sky130_fd_sc_hd__a211oi_1
X_1269_ _1269_/A _1273_/C VGND VGND VDPWR VDPWR _1269_/Y sky130_fd_sc_hd__nor2_1
XFILLER_51_174 VGND VGND VDPWR VDPWR sky130_fd_sc_hd__decap_3
XFILLER_61_38 VGND VGND VDPWR VDPWR sky130_fd_sc_hd__decap_3
XFILLER_51_60 VGND VGND VDPWR VDPWR sky130_fd_sc_hd__fill_2
XFILLER_65_211 VGND VGND VDPWR VDPWR sky130_fd_sc_hd__decap_3
X_2310_ _2310_/A VGND VGND VDPWR VDPWR uio_oe[3] sky130_fd_sc_hd__buf_2
X_2241_ clkload3/A _2241_/D _1803_/A VGND VGND VDPWR VDPWR _2241_/Q sky130_fd_sc_hd__dfrtp_1
X_2172_ _2175_/CLK _2172_/D VGND VGND VDPWR VDPWR _2172_/Q sky130_fd_sc_hd__dfxtp_1
X_1054_ _1848_/B _2234_/Q VGND VGND VDPWR VDPWR _1727_/B sky130_fd_sc_hd__and2_1
X_1123_ _1135_/B _1148_/A VGND VGND VDPWR VDPWR _1210_/A sky130_fd_sc_hd__nor2_1
X_1956_ wire69/X _1951_/Y _1803_/A VGND VGND VDPWR VDPWR _1957_/B sky130_fd_sc_hd__o21ai_1
X_1887_ _2152_/Q _1887_/B _1887_/C VGND VGND VDPWR VDPWR _1887_/Y sky130_fd_sc_hd__nand3_1
XFILLER_56_211 VGND VGND VDPWR VDPWR sky130_fd_sc_hd__fill_1
XFILLER_71_214 VGND VGND VDPWR VDPWR sky130_fd_sc_hd__fill_1
XFILLER_71_236 VGND VGND VDPWR VDPWR sky130_fd_sc_hd__fill_2
XFILLER_71_269 VGND VGND VDPWR VDPWR sky130_fd_sc_hd__decap_3
XTAP_TAPCELL_ROW_49_206 VGND VDPWR sky130_fd_sc_hd__tapvpwrvgnd_1
XFILLER_46_93 VGND VGND VDPWR VDPWR sky130_fd_sc_hd__decap_3
XFILLER_47_255 VGND VGND VDPWR VDPWR sky130_fd_sc_hd__fill_2
XFILLER_62_258 VGND VGND VDPWR VDPWR sky130_fd_sc_hd__decap_3
Xmax_cap83 _1424_/A VGND VGND VDPWR VDPWR _2116_/A sky130_fd_sc_hd__buf_2
Xmax_cap94 _2177_/Q VGND VGND VDPWR VDPWR max_cap94/X sky130_fd_sc_hd__buf_6
XFILLER_30_188 VGND VGND VDPWR VDPWR sky130_fd_sc_hd__decap_3
X_1810_ _1809_/Y _2153_/Q _1931_/S VGND VGND VDPWR VDPWR _2153_/D sky130_fd_sc_hd__mux2_1
X_1741_ _2133_/Q _2132_/Q _1741_/C VGND VGND VDPWR VDPWR _1743_/B sky130_fd_sc_hd__nor3_1
Xclkbuf_0_u_sub.u_core.u_cg_wb_lo.gclk_o u_sub.u_core.u_cg_wb_lo.u_icg/GCLK VGND VGND
+ VDPWR VDPWR clkbuf_0_u_sub.u_core.u_cg_wb_lo.gclk_o/X sky130_fd_sc_hd__clkbuf_2
X_1672_ wire85/X _1672_/B VGND VGND VDPWR VDPWR _1885_/A sky130_fd_sc_hd__nand2_1
X_1106_ _1627_/A _1614_/A VGND VGND VDPWR VDPWR _1578_/A sky130_fd_sc_hd__nand2_1
X_2224_ clkload9/A _2224_/D VGND VGND VDPWR VDPWR _2224_/Q sky130_fd_sc_hd__dfxtp_1
X_2155_ _2291_/CLK _2155_/D _2291_/D VGND VGND VDPWR VDPWR _2155_/Q sky130_fd_sc_hd__dfrtp_1
XTAP_TAPCELL_ROW_63_275 VGND VDPWR sky130_fd_sc_hd__tapvpwrvgnd_1
X_2086_ _2088_/A _2098_/B _2085_/Y VGND VGND VDPWR VDPWR _2214_/D sky130_fd_sc_hd__a21oi_1
X_1939_ _2188_/Q _1951_/B VGND VGND VDPWR VDPWR _1939_/Y sky130_fd_sc_hd__nand2_1
XFILLER_29_200 VGND VGND VDPWR VDPWR sky130_fd_sc_hd__decap_3
XFILLER_29_222 VGND VGND VDPWR VDPWR sky130_fd_sc_hd__fill_1
XTAP_TAPCELL_ROW_54_231 VGND VDPWR sky130_fd_sc_hd__tapvpwrvgnd_1
XFILLER_12_188 VGND VGND VDPWR VDPWR sky130_fd_sc_hd__fill_1
XTAP_TAPCELL_ROW_77_345 VGND VDPWR sky130_fd_sc_hd__tapvpwrvgnd_1
XFILLER_35_214 VGND VGND VDPWR VDPWR sky130_fd_sc_hd__fill_1
XFILLER_43_291 VGND VGND VDPWR VDPWR sky130_fd_sc_hd__fill_2
X_1724_ _2277_/Q _1727_/B VGND VGND VDPWR VDPWR _1726_/A sky130_fd_sc_hd__nor2_1
XTAP_TAPCELL_ROW_68_301 VGND VDPWR sky130_fd_sc_hd__tapvpwrvgnd_1
Xhold137 _2218_/Q VGND VGND VDPWR VDPWR hold137/X sky130_fd_sc_hd__dlygate4sd3_1
X_1655_ _2170_/Q _1656_/B _1656_/C _1853_/D VGND VGND VDPWR VDPWR _1655_/X sky130_fd_sc_hd__and4_1
X_1586_ _1608_/A VGND VGND VDPWR VDPWR _1599_/B sky130_fd_sc_hd__inv_1
XFILLER_41_206 VGND VGND VDPWR VDPWR sky130_fd_sc_hd__decap_3
X_2207_ _2291_/CLK _2207_/D VGND VGND VDPWR VDPWR _2207_/Q sky130_fd_sc_hd__dfxtp_1
X_2138_ clkload3/A _2138_/D VGND VGND VDPWR VDPWR _2138_/Q sky130_fd_sc_hd__dfxtp_1
X_2069_ _2088_/A _2093_/B _2068_/Y VGND VGND VDPWR VDPWR _2210_/D sky130_fd_sc_hd__a21oi_1
XTAP_TAPCELL_ROW_51_212 VGND VDPWR sky130_fd_sc_hd__tapvpwrvgnd_1
XFILLER_67_103 VGND VGND VDPWR VDPWR sky130_fd_sc_hd__fill_1
X_1440_ _1488_/B _1488_/C VGND VGND VDPWR VDPWR _2042_/D sky130_fd_sc_hd__nand2_1
X_1371_ _1200_/Y _1221_/Y _1209_/A VGND VGND VDPWR VDPWR _1371_/Y sky130_fd_sc_hd__o21ai_1
XFILLER_23_228 VGND VGND VDPWR VDPWR sky130_fd_sc_hd__decap_3
X_1707_ _1921_/A _1707_/B VGND VGND VDPWR VDPWR _1708_/C sky130_fd_sc_hd__nor2_1
X_1638_ _1638_/A _1638_/B VGND VGND VDPWR VDPWR _1638_/Y sky130_fd_sc_hd__nand2_1
XFILLER_58_125 VGND VGND VDPWR VDPWR sky130_fd_sc_hd__decap_3
XFILLER_58_169 VGND VGND VDPWR VDPWR sky130_fd_sc_hd__decap_3
X_1569_ _1517_/A _1451_/B _1568_/Y _1449_/X _1581_/A VGND VGND VDPWR VDPWR _1592_/B
+ sky130_fd_sc_hd__o32ai_1
XFILLER_14_206 VGND VGND VDPWR VDPWR sky130_fd_sc_hd__decap_3
XFILLER_49_114 VGND VGND VDPWR VDPWR sky130_fd_sc_hd__decap_3
XFILLER_45_342 VGND VGND VDPWR VDPWR sky130_fd_sc_hd__decap_3
XFILLER_57_180 VGND VGND VDPWR VDPWR sky130_fd_sc_hd__decap_3
XFILLER_60_323 VGND VGND VDPWR VDPWR sky130_fd_sc_hd__fill_1
XFILLER_9_210 VGND VGND VDPWR VDPWR sky130_fd_sc_hd__decap_3
XFILLER_9_232 VGND VGND VDPWR VDPWR sky130_fd_sc_hd__decap_3
X_1423_ _2034_/S hold51/A _1421_/Y VGND VGND VDPWR VDPWR _1432_/B sky130_fd_sc_hd__o21ai_1
X_1354_ _1389_/A _1351_/Y _1352_/Y _1353_/Y VGND VGND VDPWR VDPWR _1354_/Y sky130_fd_sc_hd__o22ai_1
X_1285_ hold55/A _1057_/Y _1101_/Y hold63/A VGND VGND VDPWR VDPWR _1286_/B sky130_fd_sc_hd__o22ai_1
XFILLER_63_150 VGND VGND VDPWR VDPWR sky130_fd_sc_hd__decap_3
Xclkload7 clkload7/A VGND VGND VDPWR VDPWR clkload7/Y sky130_fd_sc_hd__inv_4
Xu_sub.u_core.u_regfile.g_port\[2\].u_zb u_sub.u_core.u_regfile.g_port\[2\].u_b/X
+ _1181_/X VGND VGND VDPWR VDPWR _1328_/A1 sky130_fd_sc_hd__and2_1
XFILLER_61_109 VGND VGND VDPWR VDPWR sky130_fd_sc_hd__fill_2
XFILLER_49_93 VGND VGND VDPWR VDPWR sky130_fd_sc_hd__fill_1
XPHY_EDGE_ROW_19_2_2_Left_8 VGND VDPWR sky130_fd_sc_hd__tapvpwrvgnd_1
XFILLER_33_312 VGND VGND VDPWR VDPWR sky130_fd_sc_hd__fill_1
XFILLER_33_334 VGND VGND VDPWR VDPWR sky130_fd_sc_hd__decap_3
XFILLER_37_128 VGND VGND VDPWR VDPWR sky130_fd_sc_hd__fill_2
XFILLER_45_194 VGND VGND VDPWR VDPWR sky130_fd_sc_hd__fill_1
X_1070_ _1122_/C _1214_/A _1131_/C _1131_/D VGND VGND VDPWR VDPWR _1070_/Y sky130_fd_sc_hd__nor4bb_1
X_1972_ _2193_/Q _1972_/B VGND VGND VDPWR VDPWR _1974_/A sky130_fd_sc_hd__nor2_1
XFILLER_53_1 VGND VGND VDPWR VDPWR sky130_fd_sc_hd__fill_1
X_1406_ _1848_/B _2237_/Q VGND VGND VDPWR VDPWR _2002_/A sky130_fd_sc_hd__nand2_1
X_1337_ _1914_/S _1401_/A _1367_/C VGND VGND VDPWR VDPWR _1337_/Y sky130_fd_sc_hd__nor3_1
X_1268_ _1271_/A _1271_/B VGND VGND VDPWR VDPWR _1268_/Y sky130_fd_sc_hd__nor2_1
XFILLER_36_150 VGND VGND VDPWR VDPWR sky130_fd_sc_hd__decap_3
XFILLER_43_109 VGND VGND VDPWR VDPWR sky130_fd_sc_hd__fill_2
XFILLER_61_17 VGND VGND VDPWR VDPWR sky130_fd_sc_hd__decap_3
X_1199_ _1199_/A _1199_/B _1199_/C VGND VGND VDPWR VDPWR _1205_/B sky130_fd_sc_hd__nor3_1
XFILLER_3_205 VGND VGND VDPWR VDPWR sky130_fd_sc_hd__decap_3
Xu_sub.u_core.u_regfile.g_nibsel\[1\].g_nib\[2\].u_lo u_sub.u_core.u_regfile.g_word\[1\].g_byte\[0\].u_lat/Q2
+ u_sub.u_core.u_regfile.g_word\[1\].g_byte\[0\].u_lat/Q6 u_sub.u_core.u_regfile.g_word\[1\].g_byte\[1\].u_lat/Q2
+ u_sub.u_core.u_regfile.g_word\[1\].g_byte\[1\].u_lat/Q6 max_cap6/X max_cap3/X VGND
+ VGND VDPWR VDPWR u_sub.u_core.u_regfile.g_nibsel\[1\].g_nib\[2\].u_lo/X tg_mux4_x1
XFILLER_59_242 VGND VGND VDPWR VDPWR sky130_fd_sc_hd__decap_3
XPHY_EDGE_ROW_45_Right_64 VGND VDPWR sky130_fd_sc_hd__tapvpwrvgnd_1
XFILLER_35_62 VGND VGND VDPWR VDPWR sky130_fd_sc_hd__fill_2
XFILLER_42_131 VGND VGND VDPWR VDPWR sky130_fd_sc_hd__decap_3
XFILLER_51_83 VGND VGND VDPWR VDPWR sky130_fd_sc_hd__fill_2
XPHY_EDGE_ROW_54_Right_73 VGND VDPWR sky130_fd_sc_hd__tapvpwrvgnd_1
X_2240_ _2291_/CLK ui_in[7] _2291_/D VGND VGND VDPWR VDPWR _2241_/D sky130_fd_sc_hd__dfrtp_1
X_2171_ clkload4/A _2171_/D VGND VGND VDPWR VDPWR _2171_/Q sky130_fd_sc_hd__dfxtp_1
X_1122_ _1131_/C _1131_/D _1122_/C _1122_/D VGND VGND VDPWR VDPWR _1148_/A sky130_fd_sc_hd__nand4_1
XPHY_EDGE_ROW_63_Right_82 VGND VDPWR sky130_fd_sc_hd__tapvpwrvgnd_1
X_1053_ _2259_/Q _2243_/Q _2034_/S VGND VGND VDPWR VDPWR _1748_/A sky130_fd_sc_hd__mux2_1
XPHY_EDGE_ROW_72_Right_91 VGND VDPWR sky130_fd_sc_hd__tapvpwrvgnd_1
X_1955_ _2188_/Q _1961_/B VGND VGND VDPWR VDPWR _1957_/A sky130_fd_sc_hd__nor2_1
X_1886_ _1885_/A _1880_/Y _1885_/Y VGND VGND VDPWR VDPWR _1886_/Y sky130_fd_sc_hd__a21oi_1
XFILLER_56_234 VGND VGND VDPWR VDPWR sky130_fd_sc_hd__decap_3
XFILLER_24_197 VGND VGND VDPWR VDPWR sky130_fd_sc_hd__decap_3
XFILLER_47_212 VGND VGND VDPWR VDPWR sky130_fd_sc_hd__decap_3
XFILLER_70_270 VGND VGND VDPWR VDPWR sky130_fd_sc_hd__fill_2
Xmax_cap84 _1844_/B VGND VGND VDPWR VDPWR _1842_/B sky130_fd_sc_hd__clkbuf_2
XFILLER_15_197 VGND VGND VDPWR VDPWR sky130_fd_sc_hd__decap_3
XFILLER_62_60 VGND VGND VDPWR VDPWR sky130_fd_sc_hd__decap_3
Xu_sub.u_core.u_regfile.g_word\[3\].g_byte\[1\].u_lat wire103/X wire101/X wire100/X
+ wire97/X wire95/X max_cap93/X max_cap91/X max_cap89/X u_sub.u_core.u_regfile.g_word\[3\].g_byte\[1\].u_lat/GATE
+ VGND VDPWR u_sub.u_core.u_regfile.g_word\[3\].g_byte\[1\].u_lat/Q0 u_sub.u_core.u_regfile.g_word\[3\].g_byte\[1\].u_lat/Q1
+ u_sub.u_core.u_regfile.g_word\[3\].g_byte\[1\].u_lat/Q2 u_sub.u_core.u_regfile.g_word\[3\].g_byte\[1\].u_lat/Q3
+ u_sub.u_core.u_regfile.g_word\[3\].g_byte\[1\].u_lat/Q4 u_sub.u_core.u_regfile.g_word\[3\].g_byte\[1\].u_lat/Q5
+ u_sub.u_core.u_regfile.g_word\[3\].g_byte\[1\].u_lat/Q6 u_sub.u_core.u_regfile.g_word\[3\].g_byte\[1\].u_lat/Q7
+ dlxtp8_x1
X_1740_ _1740_/A wire81/X _1740_/C VGND VGND VDPWR VDPWR _1744_/A sky130_fd_sc_hd__nand3_1
X_1671_ _1671_/A _1881_/C VGND VGND VDPWR VDPWR _1672_/B sky130_fd_sc_hd__nor2_1
XFILLER_38_289 VGND VGND VDPWR VDPWR sky130_fd_sc_hd__fill_2
XPHY_EDGE_ROW_38_2_2_Right_57 VGND VDPWR sky130_fd_sc_hd__tapvpwrvgnd_1
X_1105_ _2155_/Q _2154_/Q VGND VGND VDPWR VDPWR _1322_/B sky130_fd_sc_hd__nor2_1
X_2223_ clkload9/A _2223_/D VGND VGND VDPWR VDPWR hold65/A sky130_fd_sc_hd__dfxtp_1
X_2154_ _2291_/CLK _2154_/D _2291_/D VGND VGND VDPWR VDPWR _2154_/Q sky130_fd_sc_hd__dfrtp_1
X_2085_ _2214_/Q _2088_/A _2123_/A VGND VGND VDPWR VDPWR _2085_/Y sky130_fd_sc_hd__o21ai_1
XTAP_TAPCELL_ROW_63_276 VGND VDPWR sky130_fd_sc_hd__tapvpwrvgnd_1
X_1938_ _1938_/A _1938_/B VGND VGND VDPWR VDPWR _1938_/Y sky130_fd_sc_hd__nand2_1
X_1869_ _2180_/Q _1829_/B _1267_/A VGND VGND VDPWR VDPWR _1870_/D sky130_fd_sc_hd__o21ai_1
XFILLER_67_16 VGND VGND VDPWR VDPWR sky130_fd_sc_hd__decap_3
XFILLER_57_60 VGND VGND VDPWR VDPWR sky130_fd_sc_hd__fill_2
XTAP_TAPCELL_ROW_77_346 VGND VDPWR sky130_fd_sc_hd__tapvpwrvgnd_1
XFILLER_35_248 VGND VGND VDPWR VDPWR sky130_fd_sc_hd__fill_2
XTAP_TAPCELL_ROW_60_257 VGND VDPWR sky130_fd_sc_hd__tapvpwrvgnd_1
Xclkbuf_1_1__f_u_sub.u_core.u_cg_wb_hi.gclk_o clkbuf_0_u_sub.u_core.u_cg_wb_hi.gclk_o/X
+ VGND VGND VDPWR VDPWR _2178_/CLK sky130_fd_sc_hd__clkbuf_2
Xhold127 _2196_/Q VGND VGND VDPWR VDPWR _1397_/A sky130_fd_sc_hd__dlygate4sd3_1
Xhold138 _2180_/Q VGND VGND VDPWR VDPWR hold138/X sky130_fd_sc_hd__dlygate4sd3_1
X_1723_ _1723_/A _1723_/B VGND VGND VDPWR VDPWR _2288_/D sky130_fd_sc_hd__nor2_1
X_1654_ _1853_/D VGND VGND VDPWR VDPWR _1654_/Y sky130_fd_sc_hd__inv_1
X_2206_ _2291_/CLK _2206_/D VGND VGND VDPWR VDPWR _2206_/Q sky130_fd_sc_hd__dfxtp_1
X_1585_ _1609_/A _1610_/B VGND VGND VDPWR VDPWR _1608_/A sky130_fd_sc_hd__nand2_1
X_2137_ clkload8/A _2137_/D VGND VGND VDPWR VDPWR _2137_/Q sky130_fd_sc_hd__dfxtp_1
X_2068_ _2210_/Q _2088_/A _2123_/A VGND VGND VDPWR VDPWR _2068_/Y sky130_fd_sc_hd__o21ai_1
XTAP_TAPCELL_ROW_51_213 VGND VDPWR sky130_fd_sc_hd__tapvpwrvgnd_1
XTAP_TAPCELL_ROW_74_327 VGND VDPWR sky130_fd_sc_hd__tapvpwrvgnd_1
XFILLER_43_95 VGND VGND VDPWR VDPWR sky130_fd_sc_hd__decap_3
X_1370_ _1914_/S _1208_/A _1297_/Y _1369_/Y VGND VGND VDPWR VDPWR _1370_/X sky130_fd_sc_hd__a211o_1
XFILLER_67_159 VGND VGND VDPWR VDPWR sky130_fd_sc_hd__decap_3
XPHY_EDGE_ROW_22_2_2_Right_41 VGND VDPWR sky130_fd_sc_hd__tapvpwrvgnd_1
Xclkbuf_1_0__f_u_sub.u_core.epc_gclk clkbuf_0_u_sub.u_core.epc_gclk/X VGND VGND VDPWR
+ VDPWR _2289_/CLK sky130_fd_sc_hd__clkbuf_2
X_1706_ _1898_/B _1705_/Y _1686_/Y VGND VGND VDPWR VDPWR _1707_/B sky130_fd_sc_hd__a21oi_1
X_1637_ _1638_/A _1638_/B VGND VGND VDPWR VDPWR _1639_/A sky130_fd_sc_hd__nor2_1
XFILLER_58_148 VGND VGND VDPWR VDPWR sky130_fd_sc_hd__fill_2
XFILLER_66_181 VGND VGND VDPWR VDPWR sky130_fd_sc_hd__decap_3
X_1568_ _1606_/B _1568_/B VGND VGND VDPWR VDPWR _1568_/Y sky130_fd_sc_hd__xnor2_1
X_1499_ _2117_/A _2112_/A _1499_/C _1732_/D VGND VGND VDPWR VDPWR _1612_/B sky130_fd_sc_hd__or4_1
XFILLER_49_137 VGND VGND VDPWR VDPWR sky130_fd_sc_hd__fill_2
XFILLER_49_148 VGND VGND VDPWR VDPWR sky130_fd_sc_hd__fill_2
XFILLER_38_84 VGND VGND VDPWR VDPWR sky130_fd_sc_hd__decap_3
XFILLER_49_159 VGND VGND VDPWR VDPWR sky130_fd_sc_hd__decap_3
XFILLER_57_192 VGND VGND VDPWR VDPWR sky130_fd_sc_hd__decap_3
XFILLER_9_222 VGND VGND VDPWR VDPWR sky130_fd_sc_hd__fill_2
X_1422_ _2034_/S hold51/A _1421_/Y VGND VGND VDPWR VDPWR _2116_/B sky130_fd_sc_hd__o21a_1
XFILLER_55_129 VGND VGND VDPWR VDPWR sky130_fd_sc_hd__decap_3
X_1353_ _1266_/B _1351_/Y _1269_/Y VGND VGND VDPWR VDPWR _1353_/Y sky130_fd_sc_hd__a21oi_1
X_1284_ hold62/A _1572_/A _1578_/A _2244_/Q VGND VGND VDPWR VDPWR _1286_/A sky130_fd_sc_hd__o22ai_1
XFILLER_48_181 VGND VGND VDPWR VDPWR sky130_fd_sc_hd__fill_2
Xclkload8 clkload8/A VGND VGND VDPWR VDPWR clkload8/X sky130_fd_sc_hd__clkbuf_2
XFILLER_39_192 VGND VGND VDPWR VDPWR sky130_fd_sc_hd__decap_3
Xu_sub.u_core.u_regfile.g_nibsel\[2\].g_nib\[0\].u_lo u_sub.u_core.u_regfile.g_word\[2\].g_byte\[0\].u_lat/Q0
+ u_sub.u_core.u_regfile.g_word\[2\].g_byte\[0\].u_lat/Q4 u_sub.u_core.u_regfile.g_word\[2\].g_byte\[1\].u_lat/Q0
+ u_sub.u_core.u_regfile.g_word\[2\].g_byte\[1\].u_lat/Q4 max_cap7/X max_cap4/X VGND
+ VGND VDPWR VDPWR u_sub.u_core.u_regfile.g_nibsel\[2\].g_nib\[0\].u_lo/X tg_mux4_x1
X_1971_ _1971_/A _1971_/B VGND VGND VDPWR VDPWR _2192_/D sky130_fd_sc_hd__nor2_1
XFILLER_46_1 VGND VGND VDPWR VDPWR sky130_fd_sc_hd__fill_1
X_1405_ _1848_/B _2237_/Q VGND VGND VDPWR VDPWR _2121_/B sky130_fd_sc_hd__and2_1
XFILLER_36_140 VGND VGND VDPWR VDPWR sky130_fd_sc_hd__fill_1
XFILLER_36_162 VGND VGND VDPWR VDPWR sky130_fd_sc_hd__fill_2
X_1336_ _1848_/A _1152_/B _1208_/B VGND VGND VDPWR VDPWR _1336_/Y sky130_fd_sc_hd__o21ai_1
X_1267_ _1267_/A _1267_/B VGND VGND VDPWR VDPWR _1275_/A sky130_fd_sc_hd__nand2_1
X_1198_ _1198_/A _1198_/B VGND VGND VDPWR VDPWR _1615_/D sky130_fd_sc_hd__nand2_1
XTAP_TAPCELL_ROW_46_190 VGND VDPWR sky130_fd_sc_hd__tapvpwrvgnd_1
XFILLER_3_217 VGND VGND VDPWR VDPWR sky130_fd_sc_hd__decap_3
XFILLER_42_143 VGND VGND VDPWR VDPWR sky130_fd_sc_hd__decap_3
XFILLER_32_7 VGND VGND VDPWR VDPWR sky130_fd_sc_hd__decap_3
XFILLER_65_235 VGND VGND VDPWR VDPWR sky130_fd_sc_hd__decap_3
XFILLER_65_268 VGND VGND VDPWR VDPWR sky130_fd_sc_hd__fill_1
X_1052_ _1052_/A VGND VGND VDPWR VDPWR _1052_/Y sky130_fd_sc_hd__inv_1
X_2170_ clkload7/A _2170_/D VGND VGND VDPWR VDPWR _2170_/Q sky130_fd_sc_hd__dfxtp_1
X_1121_ wire70/A _1248_/C _1648_/S VGND VGND VDPWR VDPWR _1251_/A sky130_fd_sc_hd__and3_1
X_1954_ _1954_/A _1954_/B VGND VGND VDPWR VDPWR _2187_/D sky130_fd_sc_hd__nor2_1
X_1885_ _1885_/A _1884_/Y VGND VGND VDPWR VDPWR _1885_/Y sky130_fd_sc_hd__nor2b_1
XFILLER_71_205 VGND VGND VDPWR VDPWR sky130_fd_sc_hd__decap_3
XFILLER_71_227 VGND VGND VDPWR VDPWR sky130_fd_sc_hd__decap_3
XTAP_TAPCELL_ROW_20_2_2_145 VGND VDPWR sky130_fd_sc_hd__tapvpwrvgnd_1
X_2299_ _2303_/D _2299_/GATE VGND VGND VDPWR VDPWR _2299_/Q sky130_fd_sc_hd__dlxtp_1
X_1319_ _2260_/Q _1465_/C _1318_/Y VGND VGND VDPWR VDPWR _1320_/B sky130_fd_sc_hd__a21oi_1
Xdelaybuf_2_clk delaybuf_2_clk/A VGND VGND VDPWR VDPWR delaybuf_3_clk/A sky130_fd_sc_hd__clkbuf_2
XFILLER_47_202 VGND VGND VDPWR VDPWR sky130_fd_sc_hd__decap_3
XPHY_EDGE_ROW_19_2_2_Right_38 VGND VDPWR sky130_fd_sc_hd__tapvpwrvgnd_1
XFILLER_62_50 VGND VGND VDPWR VDPWR sky130_fd_sc_hd__fill_1
XFILLER_70_260 VGND VGND VDPWR VDPWR sky130_fd_sc_hd__decap_3
Xmax_cap74 _2041_/A VGND VGND VDPWR VDPWR _2197_/D sky130_fd_sc_hd__buf_2
Xmax_cap96 _2176_/Q VGND VGND VDPWR VDPWR wire95/A sky130_fd_sc_hd__buf_6
X_1670_ _1669_/Y _1903_/B _1904_/A VGND VGND VDPWR VDPWR _1680_/B sky130_fd_sc_hd__mux2_1
XFILLER_38_202 VGND VGND VDPWR VDPWR sky130_fd_sc_hd__fill_2
X_2222_ clkload9/A _2222_/D VGND VGND VDPWR VDPWR _2222_/Q sky130_fd_sc_hd__dfxtp_1
XFILLER_38_268 VGND VGND VDPWR VDPWR sky130_fd_sc_hd__fill_1
X_1104_ hold53/A _1826_/B VGND VGND VDPWR VDPWR _1108_/A sky130_fd_sc_hd__nand2_1
X_2153_ clkload4/A _2153_/D VGND VGND VDPWR VDPWR _2153_/Q sky130_fd_sc_hd__dfxtp_1
X_2084_ _2087_/B _2084_/B VGND VGND VDPWR VDPWR _2098_/B sky130_fd_sc_hd__nand2_1
X_1937_ wire2/X _1934_/Y _1935_/Y _1936_/Y VGND VGND VDPWR VDPWR _2182_/D sky130_fd_sc_hd__a31oi_1
X_1868_ _2171_/Q wire86/X VGND VGND VDPWR VDPWR _1868_/Y sky130_fd_sc_hd__nor2_1
X_1799_ _1733_/Y _1798_/X _1803_/A VGND VGND VDPWR VDPWR _2148_/D sky130_fd_sc_hd__o21a_1
XFILLER_29_235 VGND VGND VDPWR VDPWR sky130_fd_sc_hd__fill_1
XFILLER_44_238 VGND VGND VDPWR VDPWR sky130_fd_sc_hd__decap_3
XFILLER_32_31 VGND VGND VDPWR VDPWR sky130_fd_sc_hd__decap_3
XFILLER_32_64 VGND VGND VDPWR VDPWR sky130_fd_sc_hd__decap_3
XFILLER_35_205 VGND VGND VDPWR VDPWR sky130_fd_sc_hd__decap_3
XFILLER_50_208 VGND VGND VDPWR VDPWR sky130_fd_sc_hd__decap_3
XTAP_TAPCELL_ROW_60_258 VGND VDPWR sky130_fd_sc_hd__tapvpwrvgnd_1
XPHY_EDGE_ROW_44_Left_103 VGND VDPWR sky130_fd_sc_hd__tapvpwrvgnd_1
Xhold128 _1280_/Y VGND VGND VDPWR VDPWR hold128/X sky130_fd_sc_hd__dlygate4sd3_1
Xhold139 _2166_/Q VGND VGND VDPWR VDPWR hold139/X sky130_fd_sc_hd__dlygate4sd3_1
X_1722_ _2244_/Q _1728_/B VGND VGND VDPWR VDPWR _1723_/B sky130_fd_sc_hd__nor2_1
X_1653_ _2157_/Q _1653_/B VGND VGND VDPWR VDPWR _1853_/D sky130_fd_sc_hd__xor2_1
X_1584_ _1591_/A _1605_/B _1607_/A VGND VGND VDPWR VDPWR _1584_/Y sky130_fd_sc_hd__nor3_1
XPHY_EDGE_ROW_53_Left_112 VGND VDPWR sky130_fd_sc_hd__tapvpwrvgnd_1
X_2205_ clkload9/A _2205_/D VGND VGND VDPWR VDPWR _2205_/Q sky130_fd_sc_hd__dfxtp_1
XFILLER_41_219 VGND VGND VDPWR VDPWR sky130_fd_sc_hd__decap_3
XTAP_TAPCELL_ROW_51_214 VGND VDPWR sky130_fd_sc_hd__tapvpwrvgnd_1
X_2136_ clkload8/A _2136_/D VGND VGND VDPWR VDPWR _2136_/Q sky130_fd_sc_hd__dfxtp_1
X_2067_ _2210_/Q _2067_/B VGND VGND VDPWR VDPWR _2093_/B sky130_fd_sc_hd__xor2_1
XPHY_EDGE_ROW_62_Left_121 VGND VDPWR sky130_fd_sc_hd__tapvpwrvgnd_1
Xu_sub.u_core.u_regfile.g_ir\[1\].u_lat _2172_/Q _2173_/Q _2174_/Q _2175_/Q _2176_/Q
+ _2177_/Q wire92/A _2179_/Q u_sub.u_core.u_regfile.g_ir\[1\].u_lat/GATE VGND VDPWR
+ _1144_/A _1075_/A _1144_/B _1075_/C _1081_/B _1081_/C _1332_/A1 _1077_/A dlxtp8_x1
XPHY_EDGE_ROW_71_Left_130 VGND VDPWR sky130_fd_sc_hd__tapvpwrvgnd_1
XTAP_TAPCELL_ROW_74_328 VGND VDPWR sky130_fd_sc_hd__tapvpwrvgnd_1
Xu_sub.u_core.u_regfile.g_nibsel\[3\].g_nib\[2\].u_m2 u_sub.u_core.u_regfile.g_nibsel\[3\].g_nib\[2\].u_lo/X
+ u_sub.u_core.u_regfile.g_nibsel\[3\].g_nib\[2\].u_hi/X max_cap75/X VGND VGND VDPWR
+ VDPWR u_sub.u_core.u_regfile.g_port\[2\].u_b/A2 sky130_fd_sc_hd__mux2_1
XFILLER_63_311 VGND VGND VDPWR VDPWR sky130_fd_sc_hd__fill_2
X_1705_ _2116_/B _1695_/Y _1704_/Y VGND VGND VDPWR VDPWR _1705_/Y sky130_fd_sc_hd__a21oi_1
Xu_sub.u_core.u_regfile.g_word\[2\].g_byte\[0\].u_cg.u_icg clkbuf_leaf_1_clk/X _1594_/X
+ VGND VGND VDPWR VDPWR u_sub.u_core.u_regfile.g_word\[2\].g_byte\[0\].u_lat/GATE
+ sky130_fd_sc_hd__dlclkp_1
X_1636_ _1044_/Y _1648_/S _1635_/Y VGND VGND VDPWR VDPWR _1638_/B sky130_fd_sc_hd__o21ai_1
X_1567_ _1506_/B wire85/X _1907_/A VGND VGND VDPWR VDPWR _1568_/B sky130_fd_sc_hd__a21oi_1
XFILLER_39_330 VGND VGND VDPWR VDPWR sky130_fd_sc_hd__fill_2
XFILLER_66_160 VGND VGND VDPWR VDPWR sky130_fd_sc_hd__decap_3
XFILLER_66_193 VGND VGND VDPWR VDPWR sky130_fd_sc_hd__decap_3
X_2119_ _1052_/Y _2225_/D _2118_/Y VGND VGND VDPWR VDPWR _2226_/D sky130_fd_sc_hd__o21ai_1
X_1498_ _2034_/S _2261_/Q _1496_/Y VGND VGND VDPWR VDPWR _1687_/B sky130_fd_sc_hd__o21ai_1
XFILLER_49_127 VGND VGND VDPWR VDPWR sky130_fd_sc_hd__decap_3
XFILLER_45_322 VGND VGND VDPWR VDPWR sky130_fd_sc_hd__fill_1
XFILLER_57_171 VGND VGND VDPWR VDPWR sky130_fd_sc_hd__decap_3
XFILLER_64_108 VGND VGND VDPWR VDPWR sky130_fd_sc_hd__fill_2
XFILLER_62_7 VGND VGND VDPWR VDPWR sky130_fd_sc_hd__decap_3
X_1421_ hold56/A _2034_/S VGND VGND VDPWR VDPWR _1421_/Y sky130_fd_sc_hd__nand2b_1
XFILLER_48_160 VGND VGND VDPWR VDPWR sky130_fd_sc_hd__decap_3
X_1352_ _1352_/A _1345_/B VGND VGND VDPWR VDPWR _1352_/Y sky130_fd_sc_hd__nor2b_1
X_1283_ _1255_/Y _1263_/B _1254_/Y VGND VGND VDPWR VDPWR _1311_/A sky130_fd_sc_hd__o21ai_1
XFILLER_63_174 VGND VGND VDPWR VDPWR sky130_fd_sc_hd__decap_3
Xclkload9 clkload9/A VGND VGND VDPWR VDPWR clkload9/Y sky130_fd_sc_hd__clkinvlp_4
X_1619_ _1848_/A _1619_/B VGND VGND VDPWR VDPWR _1620_/B sky130_fd_sc_hd__xnor2_1
X_1970_ wire69/X _1965_/X _1803_/A VGND VGND VDPWR VDPWR _1971_/B sky130_fd_sc_hd__o21ai_1
XFILLER_39_1 VGND VGND VDPWR VDPWR sky130_fd_sc_hd__decap_3
XFILLER_68_233 VGND VGND VDPWR VDPWR sky130_fd_sc_hd__decap_3
X_1404_ _2230_/Q _1811_/B VGND VGND VDPWR VDPWR _1521_/A sky130_fd_sc_hd__nand2_1
X_1335_ _1335_/A _1335_/B _1335_/C _1335_/D VGND VGND VDPWR VDPWR _1335_/Y sky130_fd_sc_hd__nor4_1
XFILLER_68_288 VGND VGND VDPWR VDPWR sky130_fd_sc_hd__decap_3
X_1266_ _1270_/B _1266_/B VGND VGND VDPWR VDPWR _1266_/X sky130_fd_sc_hd__or2_1
X_1197_ _1202_/C _1199_/B _1199_/C _1201_/C VGND VGND VDPWR VDPWR _1198_/B sky130_fd_sc_hd__nor4b_1
XFILLER_51_177 VGND VGND VDPWR VDPWR sky130_fd_sc_hd__fill_1
XTAP_TAPCELL_ROW_46_191 VGND VDPWR sky130_fd_sc_hd__tapvpwrvgnd_1
XFILLER_59_222 VGND VGND VDPWR VDPWR sky130_fd_sc_hd__decap_3
XFILLER_42_111 VGND VGND VDPWR VDPWR sky130_fd_sc_hd__fill_1
XFILLER_51_96 VGND VGND VDPWR VDPWR sky130_fd_sc_hd__fill_1
XFILLER_33_111 VGND VGND VDPWR VDPWR sky130_fd_sc_hd__decap_3
XFILLER_65_214 VGND VGND VDPWR VDPWR sky130_fd_sc_hd__decap_3
X_1051_ _1051_/A VGND VGND VDPWR VDPWR _1051_/Y sky130_fd_sc_hd__inv_1
X_1120_ _1364_/A _1141_/B _1120_/C VGND VGND VDPWR VDPWR _1120_/Y sky130_fd_sc_hd__nor3_1
XFILLER_33_133 VGND VGND VDPWR VDPWR sky130_fd_sc_hd__decap_3
XTAP_TAPCELL_ROW_43_172 VGND VDPWR sky130_fd_sc_hd__tapvpwrvgnd_1
X_1953_ wire70/X _1951_/Y _1803_/A VGND VGND VDPWR VDPWR _1954_/B sky130_fd_sc_hd__o21ai_1
X_1884_ _1884_/A _1884_/B VGND VGND VDPWR VDPWR _1884_/Y sky130_fd_sc_hd__nand2_1
Xclkbuf_1_1__f_u_sub.u_core.u_cg_wb_lo.gclk_o clkbuf_0_u_sub.u_core.u_cg_wb_lo.gclk_o/X
+ VGND VGND VDPWR VDPWR _2174_/CLK sky130_fd_sc_hd__clkbuf_2
XFILLER_56_247 VGND VGND VDPWR VDPWR sky130_fd_sc_hd__fill_2
X_2298_ _2302_/D _2299_/GATE VGND VGND VDPWR VDPWR _2298_/Q sky130_fd_sc_hd__dlxtp_1
X_1318_ _1393_/B _1876_/A _1317_/Y VGND VGND VDPWR VDPWR _1318_/Y sky130_fd_sc_hd__a21oi_1
XFILLER_71_239 VGND VGND VDPWR VDPWR sky130_fd_sc_hd__decap_3
XPHY_EDGE_ROW_18_2_2_Left_7 VGND VDPWR sky130_fd_sc_hd__tapvpwrvgnd_1
X_1249_ _1248_/C _1269_/A _1832_/B _1270_/B VGND VGND VDPWR VDPWR _1307_/A sky130_fd_sc_hd__a211oi_1
XFILLER_24_188 VGND VGND VDPWR VDPWR sky130_fd_sc_hd__decap_3
XFILLER_46_63 VGND VGND VDPWR VDPWR sky130_fd_sc_hd__fill_1
XFILLER_46_85 VGND VGND VDPWR VDPWR sky130_fd_sc_hd__fill_2
XFILLER_47_236 VGND VGND VDPWR VDPWR sky130_fd_sc_hd__fill_2
XTAP_TAPCELL_ROW_57_242 VGND VDPWR sky130_fd_sc_hd__tapvpwrvgnd_1
Xmax_cap20 _2154_/Q VGND VGND VDPWR VDPWR _1914_/S sky130_fd_sc_hd__buf_12
Xu_sub.u_core.u_regfile.g_word\[4\].g_byte\[3\].u_cg.u_icg clkbuf_leaf_2_clk/X _1605_/Y
+ VGND VGND VDPWR VDPWR u_sub.u_core.u_regfile.g_word\[4\].g_byte\[3\].u_lat/GATE
+ sky130_fd_sc_hd__dlclkp_1
XFILLER_15_188 VGND VGND VDPWR VDPWR sky130_fd_sc_hd__decap_3
XFILLER_46_96 VGND VGND VDPWR VDPWR sky130_fd_sc_hd__decap_3
Xmax_cap75 wire76/X VGND VGND VDPWR VDPWR max_cap75/X sky130_fd_sc_hd__clkbuf_2
X_2221_ clkload9/A _2221_/D VGND VGND VDPWR VDPWR _2221_/Q sky130_fd_sc_hd__dfxtp_1
X_2152_ clkload7/A _2152_/D _2291_/D VGND VGND VDPWR VDPWR _2152_/Q sky130_fd_sc_hd__dfrtp_1
X_1103_ _2155_/Q _2154_/Q VGND VGND VDPWR VDPWR _1572_/A sky130_fd_sc_hd__nand2_1
X_2083_ _2213_/Q _2082_/C _2214_/Q VGND VGND VDPWR VDPWR _2084_/B sky130_fd_sc_hd__a21o_1
X_1936_ _2182_/Q wire2/X _1803_/A VGND VGND VDPWR VDPWR _1936_/Y sky130_fd_sc_hd__o21ai_1
X_1867_ _1855_/Y _1924_/B _1856_/Y VGND VGND VDPWR VDPWR _2170_/D sky130_fd_sc_hd__a21oi_1
XTAP_TAPCELL_ROW_24_2_2_147 VGND VDPWR sky130_fd_sc_hd__tapvpwrvgnd_1
X_1798_ _1795_/B _1477_/B _2148_/Q VGND VGND VDPWR VDPWR _1798_/X sky130_fd_sc_hd__o21a_1
XFILLER_29_203 VGND VGND VDPWR VDPWR sky130_fd_sc_hd__decap_3
XFILLER_32_10 VGND VGND VDPWR VDPWR sky130_fd_sc_hd__decap_3
XFILLER_20_191 VGND VGND VDPWR VDPWR sky130_fd_sc_hd__fill_1
XPHY_EDGE_ROW_40_2_2_Right_59 VGND VDPWR sky130_fd_sc_hd__tapvpwrvgnd_1
XTAP_TAPCELL_ROW_60_259 VGND VDPWR sky130_fd_sc_hd__tapvpwrvgnd_1
X_1721_ _2276_/Q _1727_/B VGND VGND VDPWR VDPWR _1723_/A sky130_fd_sc_hd__nor2_1
Xhold129 _2195_/Q VGND VGND VDPWR VDPWR hold129/X sky130_fd_sc_hd__dlygate4sd3_1
X_1652_ _1640_/A _1639_/A _1638_/Y VGND VGND VDPWR VDPWR _1653_/B sky130_fd_sc_hd__o21ai_1
X_1583_ _1607_/A VGND VGND VDPWR VDPWR _1598_/B sky130_fd_sc_hd__inv_1
X_2204_ clkload9/A _2204_/D VGND VGND VDPWR VDPWR _2204_/Q sky130_fd_sc_hd__dfxtp_1
X_2135_ clkload8/A _2135_/D VGND VGND VDPWR VDPWR _2135_/Q sky130_fd_sc_hd__dfxtp_1
XFILLER_41_209 VGND VGND VDPWR VDPWR sky130_fd_sc_hd__decap_3
XTAP_TAPCELL_ROW_51_215 VGND VDPWR sky130_fd_sc_hd__tapvpwrvgnd_1
Xu_sub.u_core.u_regfile.g_nibsel\[4\].g_nib\[0\].u_m2 u_sub.u_core.u_regfile.g_nibsel\[4\].g_nib\[0\].u_lo/X
+ u_sub.u_core.u_regfile.g_nibsel\[4\].g_nib\[0\].u_hi/X max_cap1/X VGND VGND VDPWR
+ VDPWR u_sub.u_core.u_regfile.g_port\[0\].u_b/A3 sky130_fd_sc_hd__mux2_1
X_2066_ _2088_/A _2064_/Y _2065_/Y VGND VGND VDPWR VDPWR _2209_/D sky130_fd_sc_hd__a21oi_1
X_1919_ _1919_/A _1919_/B VGND VGND VDPWR VDPWR wire72/A sky130_fd_sc_hd__nor2_1
XTAP_TAPCELL_ROW_74_329 VGND VDPWR sky130_fd_sc_hd__tapvpwrvgnd_1
XFILLER_40_231 VGND VGND VDPWR VDPWR sky130_fd_sc_hd__fill_1
XFILLER_69_1 VGND VGND VDPWR VDPWR sky130_fd_sc_hd__decap_3
X_1704_ _1919_/A _1704_/B VGND VGND VDPWR VDPWR _1704_/Y sky130_fd_sc_hd__nor2_1
X_1635_ _2165_/Q _1635_/B _1635_/C VGND VGND VDPWR VDPWR _1635_/Y sky130_fd_sc_hd__nand3_1
X_1566_ _1566_/A _1566_/B _1566_/C VGND VGND VDPWR VDPWR wire85/A sky130_fd_sc_hd__and3_1
X_1497_ _2034_/S _2261_/Q _1496_/Y VGND VGND VDPWR VDPWR _1915_/B sky130_fd_sc_hd__o21a_1
XFILLER_14_209 VGND VGND VDPWR VDPWR sky130_fd_sc_hd__decap_3
XFILLER_39_342 VGND VGND VDPWR VDPWR sky130_fd_sc_hd__decap_3
XFILLER_66_172 VGND VGND VDPWR VDPWR sky130_fd_sc_hd__decap_3
X_2118_ _2226_/Q _2123_/A _2118_/C VGND VGND VDPWR VDPWR _2118_/Y sky130_fd_sc_hd__nand3_1
X_2049_ _2049_/A _2049_/B VGND VGND VDPWR VDPWR _2204_/D sky130_fd_sc_hd__nand2_1
XFILLER_57_161 VGND VGND VDPWR VDPWR sky130_fd_sc_hd__decap_3
XFILLER_57_183 VGND VGND VDPWR VDPWR sky130_fd_sc_hd__decap_3
XTAP_TAPCELL_ROW_70_310 VGND VDPWR sky130_fd_sc_hd__tapvpwrvgnd_1
XFILLER_9_213 VGND VGND VDPWR VDPWR sky130_fd_sc_hd__decap_3
XFILLER_9_235 VGND VGND VDPWR VDPWR sky130_fd_sc_hd__fill_1
X_1420_ _2034_/S hold52/A _1418_/Y VGND VGND VDPWR VDPWR _1691_/B sky130_fd_sc_hd__o21ai_1
X_1351_ _1345_/B _1352_/A VGND VGND VDPWR VDPWR _1351_/Y sky130_fd_sc_hd__nand2b_1
XFILLER_36_312 VGND VGND VDPWR VDPWR sky130_fd_sc_hd__decap_3
X_1282_ _1727_/B _1281_/Y hold128/X VGND VGND VDPWR VDPWR _2255_/D sky130_fd_sc_hd__o21ai_1
X_1618_ _1914_/S _1619_/B VGND VGND VDPWR VDPWR _1629_/A sky130_fd_sc_hd__nand2_1
X_1549_ _1581_/A _1517_/A _1548_/Y VGND VGND VDPWR VDPWR _2236_/D sky130_fd_sc_hd__o21ai_1
XFILLER_65_84 VGND VGND VDPWR VDPWR sky130_fd_sc_hd__fill_2
XFILLER_33_337 VGND VGND VDPWR VDPWR sky130_fd_sc_hd__decap_3
XFILLER_60_134 VGND VGND VDPWR VDPWR sky130_fd_sc_hd__fill_2
XFILLER_60_145 VGND VGND VDPWR VDPWR sky130_fd_sc_hd__fill_1
Xdelaybuf_21_clk delaybuf_21_clk/A VGND VGND VDPWR VDPWR delaybuf_21_clk/X sky130_fd_sc_hd__clkbuf_2
X_1403_ _2229_/Q _2233_/Q VGND VGND VDPWR VDPWR _1581_/A sky130_fd_sc_hd__nand2_1
X_1334_ _1156_/B _1376_/C _1101_/Y VGND VGND VDPWR VDPWR _1335_/D sky130_fd_sc_hd__a21oi_1
X_1265_ _1270_/B _1266_/B VGND VGND VDPWR VDPWR _1267_/B sky130_fd_sc_hd__nor2_1
XFILLER_51_112 VGND VGND VDPWR VDPWR sky130_fd_sc_hd__decap_3
XTAP_TAPCELL_ROW_32_2_2_151 VGND VDPWR sky130_fd_sc_hd__tapvpwrvgnd_1
X_1196_ _1182_/A _1454_/B _1194_/Y _1195_/X _1541_/A VGND VGND VDPWR VDPWR _1201_/C
+ sky130_fd_sc_hd__o221ai_1
XFILLER_51_167 VGND VGND VDPWR VDPWR sky130_fd_sc_hd__decap_3
XFILLER_51_189 VGND VGND VDPWR VDPWR sky130_fd_sc_hd__fill_2
XPHY_EDGE_ROW_34_2_2_Right_53 VGND VDPWR sky130_fd_sc_hd__tapvpwrvgnd_1
Xu_sub.u_core.u_regfile.g_word\[2\].g_byte\[0\].u_lat wire103/X wire101/X wire100/X
+ wire97/X wire95/X max_cap93/X max_cap91/X max_cap89/X u_sub.u_core.u_regfile.g_word\[2\].g_byte\[0\].u_lat/GATE
+ VGND VDPWR u_sub.u_core.u_regfile.g_word\[2\].g_byte\[0\].u_lat/Q0 u_sub.u_core.u_regfile.g_word\[2\].g_byte\[0\].u_lat/Q1
+ u_sub.u_core.u_regfile.g_word\[2\].g_byte\[0\].u_lat/Q2 u_sub.u_core.u_regfile.g_word\[2\].g_byte\[0\].u_lat/Q3
+ u_sub.u_core.u_regfile.g_word\[2\].g_byte\[0\].u_lat/Q4 u_sub.u_core.u_regfile.g_word\[2\].g_byte\[0\].u_lat/Q5
+ u_sub.u_core.u_regfile.g_word\[2\].g_byte\[0\].u_lat/Q6 u_sub.u_core.u_regfile.g_word\[2\].g_byte\[0\].u_lat/Q7
+ dlxtp8_x1
XFILLER_59_245 VGND VGND VDPWR VDPWR sky130_fd_sc_hd__decap_3
Xdelaybuf_12_clk delaybuf_12_clk/A VGND VGND VDPWR VDPWR delaybuf_13_clk/A sky130_fd_sc_hd__clkbuf_2
XFILLER_35_10 VGND VGND VDPWR VDPWR sky130_fd_sc_hd__fill_2
XFILLER_42_123 VGND VGND VDPWR VDPWR sky130_fd_sc_hd__decap_3
XFILLER_42_134 VGND VGND VDPWR VDPWR sky130_fd_sc_hd__fill_2
XFILLER_65_226 VGND VGND VDPWR VDPWR sky130_fd_sc_hd__fill_1
X_1050_ _1209_/A VGND VGND VDPWR VDPWR _1208_/A sky130_fd_sc_hd__inv_1
XPHY_EDGE_ROW_31_2_2_Left_20 VGND VDPWR sky130_fd_sc_hd__tapvpwrvgnd_1
XTAP_TAPCELL_ROW_43_173 VGND VDPWR sky130_fd_sc_hd__tapvpwrvgnd_1
X_1952_ _2187_/Q _1961_/B VGND VGND VDPWR VDPWR _1954_/A sky130_fd_sc_hd__nor2_1
X_1883_ _1882_/B _1678_/B _1882_/Y VGND VGND VDPWR VDPWR _1884_/B sky130_fd_sc_hd__a21oi_1
XFILLER_56_215 VGND VGND VDPWR VDPWR sky130_fd_sc_hd__fill_1
XFILLER_56_237 VGND VGND VDPWR VDPWR sky130_fd_sc_hd__fill_1
X_2297_ _2301_/D _2297_/GATE VGND VGND VDPWR VDPWR _2297_/Q sky130_fd_sc_hd__dlxtp_1
X_1317_ _2276_/Q _1393_/B _1277_/Y VGND VGND VDPWR VDPWR _1317_/Y sky130_fd_sc_hd__o21ai_1
X_1248_ _1871_/A _1248_/B _1248_/C _1541_/A VGND VGND VDPWR VDPWR _1273_/C sky130_fd_sc_hd__nand4_1
XFILLER_64_292 VGND VGND VDPWR VDPWR sky130_fd_sc_hd__fill_2
XFILLER_71_218 VGND VGND VDPWR VDPWR sky130_fd_sc_hd__decap_3
XTAP_TAPCELL_ROW_66_287 VGND VDPWR sky130_fd_sc_hd__tapvpwrvgnd_1
X_1179_ _1213_/B _1179_/B VGND VGND VDPWR VDPWR _1179_/Y sky130_fd_sc_hd__nand2b_1
XFILLER_47_215 VGND VGND VDPWR VDPWR sky130_fd_sc_hd__decap_3
XTAP_TAPCELL_ROW_57_243 VGND VDPWR sky130_fd_sc_hd__tapvpwrvgnd_1
Xmax_cap10 _1141_/B VGND VGND VDPWR VDPWR _1208_/B sky130_fd_sc_hd__buf_4
Xmax_cap87 _1367_/C VGND VGND VDPWR VDPWR _1377_/B1 sky130_fd_sc_hd__clkbuf_2
Xu_sub.u_core.u_regfile.g_nibsel\[4\].g_nib\[2\].u_hi u_sub.u_core.u_regfile.g_word\[4\].g_byte\[2\].u_lat/Q2
+ u_sub.u_core.u_regfile.g_word\[4\].g_byte\[2\].u_lat/Q6 u_sub.u_core.u_regfile.g_word\[4\].g_byte\[3\].u_lat/Q2
+ u_sub.u_core.u_regfile.g_word\[4\].g_byte\[3\].u_lat/Q6 max_cap6/X max_cap79/X VGND
+ VGND VDPWR VDPWR u_sub.u_core.u_regfile.g_nibsel\[4\].g_nib\[2\].u_hi/X tg_mux4_x1
XFILLER_62_63 VGND VGND VDPWR VDPWR sky130_fd_sc_hd__decap_3
XFILLER_70_295 VGND VGND VDPWR VDPWR sky130_fd_sc_hd__fill_1
Xmax_cap98 _2175_/Q VGND VGND VDPWR VDPWR wire97/A sky130_fd_sc_hd__buf_6
XFILLER_38_215 VGND VGND VDPWR VDPWR sky130_fd_sc_hd__decap_3
XFILLER_38_248 VGND VGND VDPWR VDPWR sky130_fd_sc_hd__decap_3
X_1102_ _1627_/A _1614_/A VGND VGND VDPWR VDPWR _1102_/Y sky130_fd_sc_hd__nor2_1
X_2220_ clkload9/A _2220_/D VGND VGND VDPWR VDPWR _2220_/Q sky130_fd_sc_hd__dfxtp_1
X_2151_ clkload3/A _2151_/D VGND VGND VDPWR VDPWR _2151_/Q sky130_fd_sc_hd__dfxtp_1
X_2082_ _2214_/Q _2213_/Q _2082_/C VGND VGND VDPWR VDPWR _2087_/B sky130_fd_sc_hd__nand3_1
XFILLER_61_251 VGND VGND VDPWR VDPWR sky130_fd_sc_hd__decap_3
XPHY_EDGE_ROW_32_2_2_Left_21 VGND VDPWR sky130_fd_sc_hd__tapvpwrvgnd_1
X_1935_ _1935_/A _1938_/B VGND VGND VDPWR VDPWR _1935_/Y sky130_fd_sc_hd__nand2_1
X_1866_ _1924_/B VGND VGND VDPWR VDPWR _1923_/B sky130_fd_sc_hd__inv_1
X_1797_ _1766_/B _1796_/Y _1803_/A VGND VGND VDPWR VDPWR _2147_/D sky130_fd_sc_hd__a21boi_1
XFILLER_67_19 VGND VGND VDPWR VDPWR sky130_fd_sc_hd__fill_1
XFILLER_32_22 VGND VGND VDPWR VDPWR sky130_fd_sc_hd__decap_3
XFILLER_52_262 VGND VGND VDPWR VDPWR sky130_fd_sc_hd__fill_2
XFILLER_32_77 VGND VGND VDPWR VDPWR sky130_fd_sc_hd__decap_3
XFILLER_43_251 VGND VGND VDPWR VDPWR sky130_fd_sc_hd__decap_3
X_1720_ _1720_/A _1720_/B VGND VGND VDPWR VDPWR _2287_/D sky130_fd_sc_hd__nor2_1
X_1651_ _1671_/A _1651_/B VGND VGND VDPWR VDPWR _1904_/A sky130_fd_sc_hd__xnor2_1
X_1582_ _1610_/A _1610_/B VGND VGND VDPWR VDPWR _1607_/A sky130_fd_sc_hd__nand2_1
XTAP_TAPCELL_ROW_28_2_2_149 VGND VDPWR sky130_fd_sc_hd__tapvpwrvgnd_1
X_2203_ clkload9/A _2203_/D VGND VGND VDPWR VDPWR _2203_/Q sky130_fd_sc_hd__dfxtp_1
X_2134_ clkload4/A _2134_/D VGND VGND VDPWR VDPWR _2134_/Q sky130_fd_sc_hd__dfxtp_1
X_2065_ _2209_/Q _2088_/A _2123_/A VGND VGND VDPWR VDPWR _2065_/Y sky130_fd_sc_hd__o21ai_1
XTAP_TAPCELL_ROW_51_216 VGND VDPWR sky130_fd_sc_hd__tapvpwrvgnd_1
XPHY_EDGE_ROW_33_2_2_Left_22 VGND VDPWR sky130_fd_sc_hd__tapvpwrvgnd_1
X_1918_ wire81/X _1914_/X _1917_/Y _1862_/B VGND VGND VDPWR VDPWR _1919_/B sky130_fd_sc_hd__a22oi_1
X_1849_ hold139/X wire70/A _1852_/S VGND VGND VDPWR VDPWR _2166_/D sky130_fd_sc_hd__mux2_1
XFILLER_43_98 VGND VGND VDPWR VDPWR sky130_fd_sc_hd__decap_3
XFILLER_67_129 VGND VGND VDPWR VDPWR sky130_fd_sc_hd__fill_2
X_1703_ _1614_/A _1795_/B _1702_/Y _1697_/Y _1477_/A VGND VGND VDPWR VDPWR _1704_/B
+ sky130_fd_sc_hd__o32a_1
X_1634_ _1914_/S _1619_/B _1628_/B _1626_/Y VGND VGND VDPWR VDPWR _1640_/A sky130_fd_sc_hd__a31oi_1
X_1565_ _1565_/A _1565_/B VGND VGND VDPWR VDPWR _2232_/D sky130_fd_sc_hd__nand2_1
X_1496_ _2245_/Q _2034_/S VGND VGND VDPWR VDPWR _1496_/Y sky130_fd_sc_hd__nand2b_1
XFILLER_66_140 VGND VGND VDPWR VDPWR sky130_fd_sc_hd__decap_3
XFILLER_66_184 VGND VGND VDPWR VDPWR sky130_fd_sc_hd__decap_3
X_2117_ _2117_/A _2121_/C VGND VGND VDPWR VDPWR _2118_/C sky130_fd_sc_hd__nand2_1
X_2048_ _2203_/Q _2053_/B _2048_/C VGND VGND VDPWR VDPWR _2049_/B sky130_fd_sc_hd__nand3_1
XPHY_EDGE_ROW_34_2_2_Left_23 VGND VDPWR sky130_fd_sc_hd__tapvpwrvgnd_1
Xu_sub.u_core.u_regfile.g_nibsel\[1\].g_nib\[1\].u_m2 u_sub.u_core.u_regfile.g_nibsel\[1\].g_nib\[1\].u_lo/X
+ u_sub.u_core.u_regfile.g_nibsel\[1\].g_nib\[1\].u_hi/X max_cap1/X VGND VGND VDPWR
+ VDPWR u_sub.u_core.u_regfile.g_port\[1\].u_b/A0 sky130_fd_sc_hd__mux2_1
XFILLER_38_87 VGND VGND VDPWR VDPWR sky130_fd_sc_hd__fill_1
XFILLER_57_151 VGND VGND VDPWR VDPWR sky130_fd_sc_hd__fill_1
XFILLER_57_195 VGND VGND VDPWR VDPWR sky130_fd_sc_hd__decap_3
XFILLER_13_232 VGND VGND VDPWR VDPWR sky130_fd_sc_hd__decap_3
XPHY_EDGE_ROW_79_Right_98 VGND VDPWR sky130_fd_sc_hd__tapvpwrvgnd_1
XTAP_TAPCELL_ROW_70_311 VGND VDPWR sky130_fd_sc_hd__tapvpwrvgnd_1
X_1350_ _1350_/A _1350_/B VGND VGND VDPWR VDPWR _1870_/B sky130_fd_sc_hd__xnor2_1
X_1281_ _2259_/Q _1259_/B _1465_/C _1279_/Y VGND VGND VDPWR VDPWR _1281_/Y sky130_fd_sc_hd__a31oi_1
XFILLER_63_110 VGND VGND VDPWR VDPWR sky130_fd_sc_hd__decap_3
Xclkbuf_leaf_0_clk delaybuf_15_clk/X VGND VGND VDPWR VDPWR clkload0/A sky130_fd_sc_hd__clkbuf_2
X_1617_ _1152_/B _2168_/Q _1648_/S VGND VGND VDPWR VDPWR _1619_/B sky130_fd_sc_hd__mux2_1
XFILLER_39_162 VGND VGND VDPWR VDPWR sky130_fd_sc_hd__fill_1
XFILLER_39_195 VGND VGND VDPWR VDPWR sky130_fd_sc_hd__decap_3
X_1548_ _1558_/B _1542_/Y _1547_/Y VGND VGND VDPWR VDPWR _1548_/Y sky130_fd_sc_hd__a21oi_1
X_1479_ _1479_/A _1479_/B VGND VGND VDPWR VDPWR _1479_/Y sky130_fd_sc_hd__nand2_1
XFILLER_40_66 VGND VGND VDPWR VDPWR sky130_fd_sc_hd__fill_2
XFILLER_6_228 VGND VGND VDPWR VDPWR sky130_fd_sc_hd__decap_3
XPHY_EDGE_ROW_35_2_2_Left_24 VGND VDPWR sky130_fd_sc_hd__tapvpwrvgnd_1
XPHY_EDGE_ROW_15_2_2_Right_34 VGND VDPWR sky130_fd_sc_hd__tapvpwrvgnd_1
X_1402_ _1187_/D _1062_/Y _1478_/B VGND VGND VDPWR VDPWR wire88/A sky130_fd_sc_hd__a21oi_1
X_1333_ _1339_/B _1376_/C _1057_/Y VGND VGND VDPWR VDPWR _1335_/C sky130_fd_sc_hd__a21oi_1
X_1264_ _1566_/A _1566_/B _1264_/C VGND VGND VDPWR VDPWR _1266_/B sky130_fd_sc_hd__nor3_1
XFILLER_36_121 VGND VGND VDPWR VDPWR sky130_fd_sc_hd__decap_3
XFILLER_36_187 VGND VGND VDPWR VDPWR sky130_fd_sc_hd__fill_1
XFILLER_36_198 VGND VGND VDPWR VDPWR sky130_fd_sc_hd__decap_3
X_1195_ _1195_/A _1209_/A _1195_/C VGND VGND VDPWR VDPWR _1195_/X sky130_fd_sc_hd__or3_1
XFILLER_59_257 VGND VGND VDPWR VDPWR sky130_fd_sc_hd__fill_2
XFILLER_42_146 VGND VGND VDPWR VDPWR sky130_fd_sc_hd__decap_3
XFILLER_2_231 VGND VGND VDPWR VDPWR sky130_fd_sc_hd__decap_3
XFILLER_51_76 VGND VGND VDPWR VDPWR sky130_fd_sc_hd__fill_2
XPHY_EDGE_ROW_36_2_2_Left_25 VGND VDPWR sky130_fd_sc_hd__tapvpwrvgnd_1
Xdelaybuf_5_clk delaybuf_5_clk/A VGND VGND VDPWR VDPWR delaybuf_6_clk/A sky130_fd_sc_hd__clkbuf_2
XFILLER_65_205 VGND VGND VDPWR VDPWR sky130_fd_sc_hd__decap_3
XFILLER_33_168 VGND VGND VDPWR VDPWR sky130_fd_sc_hd__fill_2
XTAP_TAPCELL_ROW_43_174 VGND VDPWR sky130_fd_sc_hd__tapvpwrvgnd_1
X_1951_ _1950_/A _1951_/B VGND VGND VDPWR VDPWR _1951_/Y sky130_fd_sc_hd__nand2b_1
X_1882_ wire85/X _1882_/B _1882_/C VGND VGND VDPWR VDPWR _1882_/Y sky130_fd_sc_hd__nor3_1
XTAP_TAPCELL_ROW_36_2_2_153 VGND VDPWR sky130_fd_sc_hd__tapvpwrvgnd_1
XFILLER_71_208 VGND VGND VDPWR VDPWR sky130_fd_sc_hd__decap_3
X_2296_ _2300_/D _2297_/GATE VGND VGND VDPWR VDPWR _2296_/Q sky130_fd_sc_hd__dlxtp_1
X_1316_ _1266_/X _1870_/A _1315_/Y VGND VGND VDPWR VDPWR _1876_/A sky130_fd_sc_hd__o21ai_1
X_1247_ _1364_/A _1615_/B _1247_/C VGND VGND VDPWR VDPWR _1270_/B sky130_fd_sc_hd__nor3_1
X_1178_ _1177_/A _1177_/B _1174_/X VGND VGND VDPWR VDPWR _1202_/C sky130_fd_sc_hd__a21oi_1
XTAP_TAPCELL_ROW_66_288 VGND VDPWR sky130_fd_sc_hd__tapvpwrvgnd_1
XFILLER_47_205 VGND VGND VDPWR VDPWR sky130_fd_sc_hd__fill_1
XFILLER_46_32 VGND VGND VDPWR VDPWR sky130_fd_sc_hd__decap_3
XTAP_TAPCELL_ROW_57_244 VGND VDPWR sky130_fd_sc_hd__tapvpwrvgnd_1
Xmax_cap11 _1332_/A1 VGND VGND VDPWR VDPWR _1871_/A sky130_fd_sc_hd__buf_6
Xmax_cap66 _1365_/Y VGND VGND VDPWR VDPWR _1833_/A sky130_fd_sc_hd__clkbuf_2
Xmax_cap99 wire100/X VGND VGND VDPWR VDPWR max_cap99/X sky130_fd_sc_hd__clkbuf_8
XFILLER_62_97 VGND VGND VDPWR VDPWR sky130_fd_sc_hd__decap_3
XPHY_EDGE_ROW_37_2_2_Left_26 VGND VDPWR sky130_fd_sc_hd__tapvpwrvgnd_1
XFILLER_38_238 VGND VGND VDPWR VDPWR sky130_fd_sc_hd__fill_1
XFILLER_53_219 VGND VGND VDPWR VDPWR sky130_fd_sc_hd__decap_3
XTAP_TAPCELL_ROW_48_200 VGND VDPWR sky130_fd_sc_hd__tapvpwrvgnd_1
X_1101_ _2155_/Q _1614_/A VGND VGND VDPWR VDPWR _1101_/Y sky130_fd_sc_hd__nand2_1
X_2150_ clkload3/A _2150_/D VGND VGND VDPWR VDPWR _2150_/Q sky130_fd_sc_hd__dfxtp_1
X_2081_ _2088_/A _2091_/B _2080_/Y VGND VGND VDPWR VDPWR _2213_/D sky130_fd_sc_hd__a21oi_1
X_1934_ _2187_/Q _1951_/B VGND VGND VDPWR VDPWR _1934_/Y sky130_fd_sc_hd__nand2_1
X_1865_ uio_in[3] _1898_/B _1859_/Y wire73/X VGND VGND VDPWR VDPWR _1924_/B sky130_fd_sc_hd__o22ai_1
X_1796_ _1796_/A _1932_/B VGND VGND VDPWR VDPWR _1796_/Y sky130_fd_sc_hd__nand2_1
XFILLER_52_241 VGND VGND VDPWR VDPWR sky130_fd_sc_hd__fill_1
X_2279_ _2290_/CLK hold36/X VGND VGND VDPWR VDPWR hold33/A sky130_fd_sc_hd__dfxtp_1
XFILLER_32_67 VGND VGND VDPWR VDPWR sky130_fd_sc_hd__fill_1
XFILLER_35_208 VGND VGND VDPWR VDPWR sky130_fd_sc_hd__decap_3
XPHY_EDGE_ROW_60_Right_79 VGND VDPWR sky130_fd_sc_hd__tapvpwrvgnd_1
Xu_sub.u_core.u_regfile.g_nibsel\[1\].g_nib\[3\].u_hi u_sub.u_core.u_regfile.g_word\[1\].g_byte\[2\].u_lat/Q3
+ u_sub.u_core.u_regfile.g_word\[1\].g_byte\[2\].u_lat/Q7 u_sub.u_core.u_regfile.g_word\[1\].g_byte\[3\].u_lat/Q3
+ u_sub.u_core.u_regfile.g_word\[1\].g_byte\[3\].u_lat/Q7 max_cap6/X max_cap3/X VGND
+ VGND VDPWR VDPWR u_sub.u_core.u_regfile.g_nibsel\[1\].g_nib\[3\].u_hi/X tg_mux4_x1
X_1650_ wire85/X _1881_/C VGND VGND VDPWR VDPWR _1651_/B sky130_fd_sc_hd__nand2_1
X_1581_ _1581_/A _1581_/B _1581_/C VGND VGND VDPWR VDPWR _1610_/B sky130_fd_sc_hd__nand3_1
XPHY_EDGE_ROW_17_2_2_Left_6 VGND VDPWR sky130_fd_sc_hd__tapvpwrvgnd_1
XPHY_EDGE_ROW_38_2_2_Left_27 VGND VDPWR sky130_fd_sc_hd__tapvpwrvgnd_1
X_2202_ _2291_/CLK _2202_/D VGND VGND VDPWR VDPWR _2310_/A sky130_fd_sc_hd__dfxtp_1
XFILLER_34_252 VGND VGND VDPWR VDPWR sky130_fd_sc_hd__fill_2
X_2133_ clkload6/A _2133_/D VGND VGND VDPWR VDPWR _2133_/Q sky130_fd_sc_hd__dfxtp_1
X_2064_ _2209_/Q _2208_/Q VGND VGND VDPWR VDPWR _2064_/Y sky130_fd_sc_hd__xnor2_1
X_1917_ _1915_/Y _1916_/Y _1614_/A VGND VGND VDPWR VDPWR _1917_/Y sky130_fd_sc_hd__a21oi_1
X_1848_ _1848_/A _1848_/B _2235_/Q VGND VGND VDPWR VDPWR _1852_/S sky130_fd_sc_hd__and3_1
X_1779_ _2142_/Q _1779_/B VGND VGND VDPWR VDPWR _1786_/C sky130_fd_sc_hd__and2_1
XFILLER_69_171 VGND VGND VDPWR VDPWR sky130_fd_sc_hd__decap_3
XFILLER_40_244 VGND VGND VDPWR VDPWR sky130_fd_sc_hd__fill_2
XFILLER_40_277 VGND VGND VDPWR VDPWR sky130_fd_sc_hd__decap_3
XFILLER_43_66 VGND VGND VDPWR VDPWR sky130_fd_sc_hd__fill_2
X_1702_ _2182_/Q _1915_/B _1862_/C _2146_/Q VGND VGND VDPWR VDPWR _1702_/Y sky130_fd_sc_hd__a22oi_1
X_1633_ _1638_/A _1633_/B VGND VGND VDPWR VDPWR _1633_/Y sky130_fd_sc_hd__nand2_1
X_1564_ _1564_/A _1564_/B _1564_/C _1564_/D VGND VGND VDPWR VDPWR _1565_/B sky130_fd_sc_hd__or4_1
XFILLER_66_163 VGND VGND VDPWR VDPWR sky130_fd_sc_hd__decap_3
XPHY_EDGE_ROW_39_2_2_Left_28 VGND VDPWR sky130_fd_sc_hd__tapvpwrvgnd_1
X_1495_ _1495_/A _1495_/B VGND VGND VDPWR VDPWR _1499_/C sky130_fd_sc_hd__nand2_1
XFILLER_66_196 VGND VGND VDPWR VDPWR sky130_fd_sc_hd__decap_3
X_2116_ _2116_/A _2116_/B _2116_/C VGND VGND VDPWR VDPWR _2121_/C sky130_fd_sc_hd__and3_1
X_2047_ _2197_/D _1987_/Y _2204_/Q VGND VGND VDPWR VDPWR _2049_/A sky130_fd_sc_hd__o21ai_1
XFILLER_38_66 VGND VGND VDPWR VDPWR sky130_fd_sc_hd__fill_2
XFILLER_57_174 VGND VGND VDPWR VDPWR sky130_fd_sc_hd__decap_3
XFILLER_9_204 VGND VGND VDPWR VDPWR sky130_fd_sc_hd__decap_3
X_1280_ _1397_/A _2195_/Q _1727_/B _1476_/B VGND VGND VDPWR VDPWR _1280_/Y sky130_fd_sc_hd__nand4_1
XFILLER_48_163 VGND VGND VDPWR VDPWR sky130_fd_sc_hd__decap_3
XFILLER_48_196 VGND VGND VDPWR VDPWR sky130_fd_sc_hd__decap_3
XFILLER_63_177 VGND VGND VDPWR VDPWR sky130_fd_sc_hd__decap_3
X_1616_ _1616_/A _1616_/B _1631_/A VGND VGND VDPWR VDPWR _1616_/Y sky130_fd_sc_hd__nor3_1
X_1547_ _1547_/A _1547_/B VGND VGND VDPWR VDPWR _1547_/Y sky130_fd_sc_hd__nand2_1
X_1478_ _1478_/A _1478_/B VGND VGND VDPWR VDPWR _1478_/X sky130_fd_sc_hd__or2_1
XFILLER_49_76 VGND VGND VDPWR VDPWR sky130_fd_sc_hd__fill_1
XFILLER_49_98 VGND VGND VDPWR VDPWR sky130_fd_sc_hd__fill_1
XFILLER_45_188 VGND VGND VDPWR VDPWR sky130_fd_sc_hd__decap_3
Xu_sub.u_core.u_regfile.g_word\[1\].g_byte\[3\].u_lat wire103/A wire102/X max_cap99/X
+ wire97/A wire95/A max_cap94/X wire92/X max_cap90/X u_sub.u_core.u_regfile.g_word\[1\].g_byte\[3\].u_lat/GATE
+ VGND VDPWR u_sub.u_core.u_regfile.g_word\[1\].g_byte\[3\].u_lat/Q0 u_sub.u_core.u_regfile.g_word\[1\].g_byte\[3\].u_lat/Q1
+ u_sub.u_core.u_regfile.g_word\[1\].g_byte\[3\].u_lat/Q2 u_sub.u_core.u_regfile.g_word\[1\].g_byte\[3\].u_lat/Q3
+ u_sub.u_core.u_regfile.g_word\[1\].g_byte\[3\].u_lat/Q4 u_sub.u_core.u_regfile.g_word\[1\].g_byte\[3\].u_lat/Q5
+ u_sub.u_core.u_regfile.g_word\[1\].g_byte\[3\].u_lat/Q6 u_sub.u_core.u_regfile.g_word\[1\].g_byte\[3\].u_lat/Q7
+ dlxtp8_x1
XFILLER_39_4 VGND VGND VDPWR VDPWR sky130_fd_sc_hd__fill_2
X_1401_ _1401_/A _1401_/B _1401_/C VGND VGND VDPWR VDPWR _1478_/B sky130_fd_sc_hd__and3_1
XFILLER_68_225 VGND VGND VDPWR VDPWR sky130_fd_sc_hd__fill_1
X_1332_ _1332_/A1 _1221_/B _1377_/B1 _1572_/A VGND VGND VDPWR VDPWR _1335_/B sky130_fd_sc_hd__a211oi_1
X_1263_ _1263_/A _1263_/B VGND VGND VDPWR VDPWR _1267_/A sky130_fd_sc_hd__xnor2_1
X_1194_ _1871_/A _1454_/B _1082_/C _1237_/A VGND VGND VDPWR VDPWR _1194_/Y sky130_fd_sc_hd__a211oi_1
XFILLER_59_225 VGND VGND VDPWR VDPWR sky130_fd_sc_hd__decap_3
XFILLER_67_280 VGND VGND VDPWR VDPWR sky130_fd_sc_hd__fill_2
XFILLER_35_89 VGND VGND VDPWR VDPWR sky130_fd_sc_hd__fill_2
XPHY_EDGE_ROW_69_Left_128 VGND VDPWR sky130_fd_sc_hd__tapvpwrvgnd_1
XFILLER_18_188 VGND VGND VDPWR VDPWR sky130_fd_sc_hd__decap_3
XFILLER_33_103 VGND VGND VDPWR VDPWR sky130_fd_sc_hd__fill_1
XFILLER_33_114 VGND VGND VDPWR VDPWR sky130_fd_sc_hd__decap_3
XTAP_TAPCELL_ROW_43_175 VGND VDPWR sky130_fd_sc_hd__tapvpwrvgnd_1
X_1950_ _1950_/A _1950_/B VGND VGND VDPWR VDPWR _1961_/B sky130_fd_sc_hd__nor2_1
XPHY_EDGE_ROW_78_Left_137 VGND VDPWR sky130_fd_sc_hd__tapvpwrvgnd_1
X_1881_ _2163_/Q wire85/X _1881_/C VGND VGND VDPWR VDPWR _1884_/A sky130_fd_sc_hd__nand3_1
XFILLER_37_1 VGND VGND VDPWR VDPWR sky130_fd_sc_hd__decap_3
X_1315_ _1389_/A _1313_/Y _1314_/Y _1312_/Y _1266_/X VGND VGND VDPWR VDPWR _1315_/Y
+ sky130_fd_sc_hd__o221ai_1
XTAP_TAPCELL_ROW_66_289 VGND VDPWR sky130_fd_sc_hd__tapvpwrvgnd_1
X_2295_ _2295_/CLK wire67/X VGND VGND VDPWR VDPWR _2303_/D sky130_fd_sc_hd__dfxtp_1
X_1246_ _1566_/C _1248_/C VGND VGND VDPWR VDPWR _1264_/C sky130_fd_sc_hd__nand2b_1
X_1177_ _1177_/A _1177_/B VGND VGND VDPWR VDPWR _1177_/Y sky130_fd_sc_hd__nand2_1
XFILLER_46_99 VGND VGND VDPWR VDPWR sky130_fd_sc_hd__fill_1
XFILLER_62_209 VGND VGND VDPWR VDPWR sky130_fd_sc_hd__decap_3
XTAP_TAPCELL_ROW_57_245 VGND VDPWR sky130_fd_sc_hd__tapvpwrvgnd_1
Xmax_cap78 _1987_/Y VGND VGND VDPWR VDPWR _2044_/B sky130_fd_sc_hd__clkbuf_4
Xmax_cap89 max_cap90/X VGND VGND VDPWR VDPWR max_cap89/X sky130_fd_sc_hd__buf_6
Xu_sub.u_core.u_regfile.g_nibsel\[4\].g_nib\[2\].u_lo u_sub.u_core.u_regfile.g_word\[4\].g_byte\[0\].u_lat/Q2
+ u_sub.u_core.u_regfile.g_word\[4\].g_byte\[0\].u_lat/Q6 u_sub.u_core.u_regfile.g_word\[4\].g_byte\[1\].u_lat/Q2
+ u_sub.u_core.u_regfile.g_word\[4\].g_byte\[1\].u_lat/Q6 max_cap6/X max_cap3/X VGND
+ VGND VDPWR VDPWR u_sub.u_core.u_regfile.g_nibsel\[4\].g_nib\[2\].u_lo/X tg_mux4_x1
XFILLER_23_191 VGND VGND VDPWR VDPWR sky130_fd_sc_hd__decap_3
Xu_sub.u_core.u_regfile.g_port\[3\].u_za u_sub.u_core.u_regfile.g_port\[3\].u_a/X
+ _1189_/C VGND VGND VDPWR VDPWR _1856_/A1 sky130_fd_sc_hd__and2_1
XFILLER_38_228 VGND VGND VDPWR VDPWR sky130_fd_sc_hd__fill_2
XFILLER_46_250 VGND VGND VDPWR VDPWR sky130_fd_sc_hd__fill_1
XTAP_TAPCELL_ROW_48_201 VGND VDPWR sky130_fd_sc_hd__tapvpwrvgnd_1
X_1100_ _1627_/A _1914_/S VGND VGND VDPWR VDPWR _1360_/B sky130_fd_sc_hd__nor2_1
X_2080_ _2213_/Q _2088_/A _2123_/A VGND VGND VDPWR VDPWR _2080_/Y sky130_fd_sc_hd__o21ai_1
XFILLER_14_191 VGND VGND VDPWR VDPWR sky130_fd_sc_hd__decap_3
XFILLER_61_231 VGND VGND VDPWR VDPWR sky130_fd_sc_hd__fill_2
XFILLER_61_242 VGND VGND VDPWR VDPWR sky130_fd_sc_hd__decap_3
X_1933_ _1950_/A _1932_/Y _1803_/A VGND VGND VDPWR VDPWR _2181_/D sky130_fd_sc_hd__a21boi_1
Xu_sub.u_core.u_regfile.g_nibsel\[2\].g_nib\[1\].u_hi u_sub.u_core.u_regfile.g_word\[2\].g_byte\[2\].u_lat/Q1
+ u_sub.u_core.u_regfile.g_word\[2\].g_byte\[2\].u_lat/Q5 u_sub.u_core.u_regfile.g_word\[2\].g_byte\[3\].u_lat/Q1
+ u_sub.u_core.u_regfile.g_word\[2\].g_byte\[3\].u_lat/Q5 max_cap7/X max_cap79/X VGND
+ VGND VDPWR VDPWR u_sub.u_core.u_regfile.g_nibsel\[2\].g_nib\[1\].u_hi/X tg_mux4_x1
X_1864_ _1861_/Y _1862_/Y _1863_/Y _1860_/Y _1919_/A VGND VGND VDPWR VDPWR wire73/A
+ sky130_fd_sc_hd__a311oi_1
X_1795_ _1795_/A _1795_/B _1965_/B VGND VGND VDPWR VDPWR _1932_/B sky130_fd_sc_hd__or3_1
XFILLER_29_206 VGND VGND VDPWR VDPWR sky130_fd_sc_hd__decap_3
XFILLER_69_331 VGND VGND VDPWR VDPWR sky130_fd_sc_hd__fill_1
X_2278_ _2290_/CLK hold26/X VGND VGND VDPWR VDPWR _2278_/Q sky130_fd_sc_hd__dfxtp_1
XFILLER_37_261 VGND VGND VDPWR VDPWR sky130_fd_sc_hd__decap_3
X_2238__22 VGND VGND VDPWR VDPWR _2238_/D _2238__22/LO sky130_fd_sc_hd__conb_1
X_1229_ _1112_/Y _1205_/Y _1228_/X _1120_/Y VGND VGND VDPWR VDPWR _1251_/B sky130_fd_sc_hd__a211oi_1
XFILLER_32_13 VGND VGND VDPWR VDPWR sky130_fd_sc_hd__decap_3
XFILLER_32_35 VGND VGND VDPWR VDPWR sky130_fd_sc_hd__decap_3
XTAP_TAPCELL_ROW_62_270 VGND VDPWR sky130_fd_sc_hd__tapvpwrvgnd_1
XPHY_EDGE_ROW_41_1_1_Left_100 VGND VDPWR sky130_fd_sc_hd__tapvpwrvgnd_1
XFILLER_43_242 VGND VGND VDPWR VDPWR sky130_fd_sc_hd__decap_3
X_1580_ _2156_/Q _1580_/B _1580_/C VGND VGND VDPWR VDPWR _1581_/C sky130_fd_sc_hd__nand3_1
X_2201_ _2291_/CLK _2201_/D VGND VGND VDPWR VDPWR uio_out[3] sky130_fd_sc_hd__dfxtp_1
X_2132_ clkload6/A _2132_/D VGND VGND VDPWR VDPWR _2132_/Q sky130_fd_sc_hd__dfxtp_1
XFILLER_34_231 VGND VGND VDPWR VDPWR sky130_fd_sc_hd__fill_2
XTAP_TAPCELL_ROW_76_340 VGND VDPWR sky130_fd_sc_hd__tapvpwrvgnd_1
X_2063_ _2209_/Q _2208_/Q VGND VGND VDPWR VDPWR _2067_/B sky130_fd_sc_hd__nand2_1
X_1916_ _2150_/Q _2149_/Q _1862_/C VGND VGND VDPWR VDPWR _1916_/Y sky130_fd_sc_hd__o21ai_1
X_1847_ wire70/A _2165_/Q _1847_/S VGND VGND VDPWR VDPWR _2165_/D sky130_fd_sc_hd__mux2_1
X_1778_ _2142_/Q _1789_/B _1779_/B VGND VGND VDPWR VDPWR _1780_/A sky130_fd_sc_hd__a21oi_1
XFILLER_40_201 VGND VGND VDPWR VDPWR sky130_fd_sc_hd__decap_3
XFILLER_48_312 VGND VGND VDPWR VDPWR sky130_fd_sc_hd__fill_1
Xu_sub.u_core.u_regfile.g_word\[3\].g_byte\[2\].u_cg.u_icg clkload0/A _1600_/X VGND
+ VGND VDPWR VDPWR u_sub.u_core.u_regfile.g_word\[3\].g_byte\[2\].u_lat/GATE sky130_fd_sc_hd__dlclkp_1
X_1701_ _1915_/B _1766_/A VGND VGND VDPWR VDPWR _1862_/C sky130_fd_sc_hd__nor2_1
XFILLER_69_4 VGND VGND VDPWR VDPWR sky130_fd_sc_hd__decap_3
X_1632_ _1627_/A _1631_/A _1853_/B VGND VGND VDPWR VDPWR _1632_/Y sky130_fd_sc_hd__o21ai_1
X_1563_ _2232_/Q _1563_/B VGND VGND VDPWR VDPWR _1565_/A sky130_fd_sc_hd__nand2_1
X_1494_ _1494_/A _2036_/A VGND VGND VDPWR VDPWR _1495_/B sky130_fd_sc_hd__nor2_1
XFILLER_58_109 VGND VGND VDPWR VDPWR sky130_fd_sc_hd__fill_2
XFILLER_66_131 VGND VGND VDPWR VDPWR sky130_fd_sc_hd__decap_3
XFILLER_66_175 VGND VGND VDPWR VDPWR sky130_fd_sc_hd__decap_3
X_2115_ _2224_/Q _2123_/A VGND VGND VDPWR VDPWR _2225_/D sky130_fd_sc_hd__nand2b_1
X_2046_ _2046_/A _2046_/B VGND VGND VDPWR VDPWR _2203_/D sky130_fd_sc_hd__nor2_1
XFILLER_38_78 VGND VGND VDPWR VDPWR sky130_fd_sc_hd__decap_3
XFILLER_54_66 VGND VGND VDPWR VDPWR sky130_fd_sc_hd__fill_2
XFILLER_57_131 VGND VGND VDPWR VDPWR sky130_fd_sc_hd__fill_2
XFILLER_57_142 VGND VGND VDPWR VDPWR sky130_fd_sc_hd__decap_3
XFILLER_57_164 VGND VGND VDPWR VDPWR sky130_fd_sc_hd__fill_1
XFILLER_57_186 VGND VGND VDPWR VDPWR sky130_fd_sc_hd__decap_3
XFILLER_36_315 VGND VGND VDPWR VDPWR sky130_fd_sc_hd__decap_3
XFILLER_48_175 VGND VGND VDPWR VDPWR sky130_fd_sc_hd__decap_3
XFILLER_48_186 VGND VGND VDPWR VDPWR sky130_fd_sc_hd__fill_2
XPHY_EDGE_ROW_50_Left_109 VGND VDPWR sky130_fd_sc_hd__tapvpwrvgnd_1
XFILLER_63_134 VGND VGND VDPWR VDPWR sky130_fd_sc_hd__decap_3
XFILLER_67_1 VGND VGND VDPWR VDPWR sky130_fd_sc_hd__decap_3
X_1615_ _1836_/B _1615_/B _1615_/C _1615_/D VGND VGND VDPWR VDPWR _1844_/B sky130_fd_sc_hd__nor4_1
X_1546_ _1560_/B _1560_/A VGND VGND VDPWR VDPWR _1547_/B sky130_fd_sc_hd__nand2b_1
X_1477_ _1477_/A _1477_/B VGND VGND VDPWR VDPWR _1477_/Y sky130_fd_sc_hd__nor2_1
X_2029_ _2294_/D _2006_/X _2028_/Y VGND VGND VDPWR VDPWR _2029_/Y sky130_fd_sc_hd__a21oi_1
Xdelaybuf_15_clk delaybuf_15_clk/A VGND VGND VDPWR VDPWR delaybuf_15_clk/X sky130_fd_sc_hd__clkbuf_2
XFILLER_49_44 VGND VGND VDPWR VDPWR sky130_fd_sc_hd__decap_3
XFILLER_5_230 VGND VGND VDPWR VDPWR sky130_fd_sc_hd__decap_3
X_1400_ _1175_/B _1179_/Y _1479_/B VGND VGND VDPWR VDPWR _1400_/X sky130_fd_sc_hd__o21a_1
X_1331_ _1075_/A _1221_/A _1222_/Y _1152_/B _1578_/A VGND VGND VDPWR VDPWR _1335_/A
+ sky130_fd_sc_hd__a221oi_1
X_1262_ _1262_/A VGND VGND VDPWR VDPWR _1263_/B sky130_fd_sc_hd__inv_1
X_1193_ _1871_/A _1454_/B VGND VGND VDPWR VDPWR _1231_/B sky130_fd_sc_hd__nand2_1
XFILLER_51_115 VGND VGND VDPWR VDPWR sky130_fd_sc_hd__fill_1
XFILLER_59_237 VGND VGND VDPWR VDPWR sky130_fd_sc_hd__fill_1
X_1529_ _2230_/Q _2158_/Q VGND VGND VDPWR VDPWR _1564_/C sky130_fd_sc_hd__nand2_1
XFILLER_35_35 VGND VGND VDPWR VDPWR sky130_fd_sc_hd__fill_1
XFILLER_42_137 VGND VGND VDPWR VDPWR sky130_fd_sc_hd__decap_3
XFILLER_42_159 VGND VGND VDPWR VDPWR sky130_fd_sc_hd__decap_3
XFILLER_2_222 VGND VGND VDPWR VDPWR sky130_fd_sc_hd__decap_3
XFILLER_41_181 VGND VGND VDPWR VDPWR sky130_fd_sc_hd__fill_2
XTAP_TAPCELL_ROW_43_176 VGND VDPWR sky130_fd_sc_hd__tapvpwrvgnd_1
X_1880_ _1904_/A _1877_/X _1879_/Y VGND VGND VDPWR VDPWR _1880_/Y sky130_fd_sc_hd__a21oi_1
X_2294_ _2294_/CLK _2294_/D VGND VGND VDPWR VDPWR _2302_/D sky130_fd_sc_hd__dfxtp_1
X_1314_ _1266_/B _1313_/Y _1269_/Y VGND VGND VDPWR VDPWR _1314_/Y sky130_fd_sc_hd__a21oi_1
X_1245_ _1364_/A _1566_/C VGND VGND VDPWR VDPWR _1832_/B sky130_fd_sc_hd__nor2_1
X_1176_ _1157_/Y _1189_/B _1175_/Y _1065_/Y VGND VGND VDPWR VDPWR _1177_/B sky130_fd_sc_hd__a22o_1
XFILLER_47_218 VGND VGND VDPWR VDPWR sky130_fd_sc_hd__fill_2
XTAP_TAPCELL_ROW_57_246 VGND VDPWR sky130_fd_sc_hd__tapvpwrvgnd_1
XFILLER_55_284 VGND VGND VDPWR VDPWR sky130_fd_sc_hd__fill_2
XFILLER_62_44 VGND VGND VDPWR VDPWR sky130_fd_sc_hd__decap_3
XFILLER_62_66 VGND VGND VDPWR VDPWR sky130_fd_sc_hd__fill_2
Xmax_cap68 _1328_/A1 VGND VGND VDPWR VDPWR _2294_/D sky130_fd_sc_hd__buf_6
Xmax_cap79 _1632_/Y VGND VGND VDPWR VDPWR max_cap79/X sky130_fd_sc_hd__clkbuf_4
Xu_sub.u_core.u_regfile.g_port\[3\].u_zb u_sub.u_core.u_regfile.g_port\[3\].u_b/X
+ _1181_/X VGND VGND VDPWR VDPWR wire67/A sky130_fd_sc_hd__and2_1
XPHY_EDGE_ROW_27_2_2_Right_46 VGND VDPWR sky130_fd_sc_hd__tapvpwrvgnd_1
XFILLER_61_254 VGND VGND VDPWR VDPWR sky130_fd_sc_hd__fill_1
X_1932_ _1932_/A _1932_/B VGND VGND VDPWR VDPWR _1932_/Y sky130_fd_sc_hd__nand2_1
X_1863_ _1614_/A _1863_/A2 wire81/X VGND VGND VDPWR VDPWR _1863_/Y sky130_fd_sc_hd__o21ai_1
XFILLER_69_310 VGND VGND VDPWR VDPWR sky130_fd_sc_hd__fill_1
X_1794_ _1794_/A _1794_/B VGND VGND VDPWR VDPWR _2146_/D sky130_fd_sc_hd__nor2_1
X_2277_ _2289_/CLK hold30/X VGND VGND VDPWR VDPWR _2277_/Q sky130_fd_sc_hd__dfxtp_1
X_1228_ _1257_/B _1226_/Y _1227_/Y _1220_/Y _1225_/X VGND VGND VDPWR VDPWR _1228_/X
+ sky130_fd_sc_hd__o311a_1
XTAP_TAPCELL_ROW_54_227 VGND VDPWR sky130_fd_sc_hd__tapvpwrvgnd_1
XTAP_TAPCELL_ROW_62_271 VGND VDPWR sky130_fd_sc_hd__tapvpwrvgnd_1
X_1159_ _1191_/A _1248_/B VGND VGND VDPWR VDPWR _1232_/B sky130_fd_sc_hd__nand2_1
XFILLER_32_25 VGND VGND VDPWR VDPWR sky130_fd_sc_hd__decap_3
XFILLER_32_58 VGND VGND VDPWR VDPWR sky130_fd_sc_hd__decap_3
XFILLER_32_69 VGND VGND VDPWR VDPWR sky130_fd_sc_hd__decap_3
XFILLER_57_88 VGND VGND VDPWR VDPWR sky130_fd_sc_hd__fill_2
XFILLER_43_298 VGND VGND VDPWR VDPWR sky130_fd_sc_hd__decap_3
Xu_sub.u_core.u_regfile.g_nibsel\[1\].g_nib\[3\].u_lo u_sub.u_core.u_regfile.g_word\[1\].g_byte\[0\].u_lat/Q3
+ u_sub.u_core.u_regfile.g_word\[1\].g_byte\[0\].u_lat/Q7 u_sub.u_core.u_regfile.g_word\[1\].g_byte\[1\].u_lat/Q3
+ u_sub.u_core.u_regfile.g_word\[1\].g_byte\[1\].u_lat/Q7 max_cap6/X max_cap3/X VGND
+ VGND VDPWR VDPWR u_sub.u_core.u_regfile.g_nibsel\[1\].g_nib\[3\].u_lo/X tg_mux4_x1
XFILLER_7_188 VGND VGND VDPWR VDPWR sky130_fd_sc_hd__decap_3
XFILLER_66_302 VGND VGND VDPWR VDPWR sky130_fd_sc_hd__fill_1
XTAP_TAPCELL_ROW_76_341 VGND VDPWR sky130_fd_sc_hd__tapvpwrvgnd_1
X_2200_ _2291_/CLK _2200_/D VGND VGND VDPWR VDPWR uio_out[2] sky130_fd_sc_hd__dfxtp_1
X_2131_ clkload3/A _2131_/D VGND VGND VDPWR VDPWR _2131_/Q sky130_fd_sc_hd__dfxtp_1
X_2062_ _2208_/Q _2088_/A _2061_/Y VGND VGND VDPWR VDPWR _2208_/D sky130_fd_sc_hd__a21oi_1
X_1915_ _2184_/Q _1915_/B VGND VGND VDPWR VDPWR _1915_/Y sky130_fd_sc_hd__nand2_1
X_1846_ _1914_/S _1848_/B _2235_/Q VGND VGND VDPWR VDPWR _1847_/S sky130_fd_sc_hd__nand3_1
X_1777_ _1803_/A _1789_/B _1777_/C VGND VGND VDPWR VDPWR _2141_/D sky130_fd_sc_hd__and3_1
XTAP_TAPCELL_ROW_73_322 VGND VDPWR sky130_fd_sc_hd__tapvpwrvgnd_1
XPHY_EDGE_ROW_11_2_2_Right_30 VGND VDPWR sky130_fd_sc_hd__tapvpwrvgnd_1
X_1700_ _2014_/A _1748_/A VGND VGND VDPWR VDPWR _1766_/A sky130_fd_sc_hd__nand2b_1
X_1631_ _1631_/A _1631_/B VGND VGND VDPWR VDPWR _1853_/B sky130_fd_sc_hd__nand2_1
Xclkbuf_leaf_3_clk clkbuf_leaf_4_clk/A VGND VGND VDPWR VDPWR clkbuf_leaf_3_clk/X sky130_fd_sc_hd__clkbuf_2
X_1562_ _1829_/A _1558_/B _1644_/B _1537_/Y _2233_/Q VGND VGND VDPWR VDPWR _2233_/D
+ sky130_fd_sc_hd__a32o_1
X_1493_ _2262_/Q _2246_/Q _2034_/S VGND VGND VDPWR VDPWR _2036_/A sky130_fd_sc_hd__mux2_1
XFILLER_54_338 VGND VGND VDPWR VDPWR sky130_fd_sc_hd__fill_2
XFILLER_66_143 VGND VGND VDPWR VDPWR sky130_fd_sc_hd__decap_3
XFILLER_66_154 VGND VGND VDPWR VDPWR sky130_fd_sc_hd__decap_3
XFILLER_66_187 VGND VGND VDPWR VDPWR sky130_fd_sc_hd__decap_3
X_2114_ hold65/X _2291_/D VGND VGND VDPWR VDPWR _2224_/D sky130_fd_sc_hd__nand2b_1
X_2045_ _2203_/Q _2053_/B VGND VGND VDPWR VDPWR _2046_/B sky130_fd_sc_hd__nor2_1
X_1829_ _1829_/A _1829_/B _1887_/C VGND VGND VDPWR VDPWR _1830_/B sky130_fd_sc_hd__nand3_1
Xu_sub.u_core.u_regfile.g_word\[4\].g_byte\[1\].u_lat wire103/A wire102/X max_cap99/X
+ wire97/A wire95/A max_cap94/X wire92/X max_cap90/X u_sub.u_core.u_regfile.g_word\[4\].g_byte\[1\].u_lat/GATE
+ VGND VDPWR u_sub.u_core.u_regfile.g_word\[4\].g_byte\[1\].u_lat/Q0 u_sub.u_core.u_regfile.g_word\[4\].g_byte\[1\].u_lat/Q1
+ u_sub.u_core.u_regfile.g_word\[4\].g_byte\[1\].u_lat/Q2 u_sub.u_core.u_regfile.g_word\[4\].g_byte\[1\].u_lat/Q3
+ u_sub.u_core.u_regfile.g_word\[4\].g_byte\[1\].u_lat/Q4 u_sub.u_core.u_regfile.g_word\[4\].g_byte\[1\].u_lat/Q5
+ u_sub.u_core.u_regfile.g_word\[4\].g_byte\[1\].u_lat/Q6 u_sub.u_core.u_regfile.g_word\[4\].g_byte\[1\].u_lat/Q7
+ dlxtp8_x1
XFILLER_57_198 VGND VGND VDPWR VDPWR sky130_fd_sc_hd__decap_3
XPHY_EDGE_ROW_16_2_2_Left_5 VGND VDPWR sky130_fd_sc_hd__tapvpwrvgnd_1
XFILLER_13_235 VGND VGND VDPWR VDPWR sky130_fd_sc_hd__fill_1
XFILLER_70_99 VGND VGND VDPWR VDPWR sky130_fd_sc_hd__decap_3
XPHY_EDGE_ROW_48_Right_67 VGND VDPWR sky130_fd_sc_hd__tapvpwrvgnd_1
XPHY_EDGE_ROW_57_Right_76 VGND VDPWR sky130_fd_sc_hd__tapvpwrvgnd_1
XFILLER_48_132 VGND VGND VDPWR VDPWR sky130_fd_sc_hd__decap_3
XFILLER_63_124 VGND VGND VDPWR VDPWR sky130_fd_sc_hd__fill_1
XPHY_EDGE_ROW_66_Right_85 VGND VDPWR sky130_fd_sc_hd__tapvpwrvgnd_1
XPHY_EDGE_ROW_75_Right_94 VGND VDPWR sky130_fd_sc_hd__tapvpwrvgnd_1
X_1614_ _1614_/A _2121_/B VGND VGND VDPWR VDPWR _1616_/B sky130_fd_sc_hd__nor2_1
X_1545_ _1148_/Y _1541_/C _1393_/B VGND VGND VDPWR VDPWR _1560_/B sky130_fd_sc_hd__a21boi_1
X_1476_ _2131_/Q _1476_/B _2117_/A VGND VGND VDPWR VDPWR _1477_/B sky130_fd_sc_hd__nand3_1
XFILLER_54_157 VGND VGND VDPWR VDPWR sky130_fd_sc_hd__decap_3
X_2028_ _2021_/Y _2027_/Y _1986_/Y VGND VGND VDPWR VDPWR _2028_/Y sky130_fd_sc_hd__a21oi_1
XFILLER_5_220 VGND VGND VDPWR VDPWR sky130_fd_sc_hd__fill_1
Xdelaybuf_8_clk delaybuf_8_clk/A VGND VGND VDPWR VDPWR delaybuf_9_clk/A sky130_fd_sc_hd__clkbuf_2
X_1330_ _1836_/B _1205_/Y _1887_/B _1329_/Y VGND VGND VDPWR VDPWR _1330_/Y sky130_fd_sc_hd__a31oi_1
X_1261_ _1307_/A _1829_/B _1260_/Y VGND VGND VDPWR VDPWR _1262_/A sky130_fd_sc_hd__a21oi_1
XFILLER_36_124 VGND VGND VDPWR VDPWR sky130_fd_sc_hd__decap_3
X_1192_ _1248_/B _1871_/A VGND VGND VDPWR VDPWR _1192_/Y sky130_fd_sc_hd__nor2b_1
XFILLER_44_190 VGND VGND VDPWR VDPWR sky130_fd_sc_hd__decap_3
X_1528_ _2158_/Q _1531_/A VGND VGND VDPWR VDPWR _1534_/B sky130_fd_sc_hd__nand2_1
X_1459_ _1848_/A _1460_/B VGND VGND VDPWR VDPWR _1459_/Y sky130_fd_sc_hd__xnor2_1
XFILLER_42_105 VGND VGND VDPWR VDPWR sky130_fd_sc_hd__decap_3
XFILLER_42_149 VGND VGND VDPWR VDPWR sky130_fd_sc_hd__fill_1
XFILLER_51_35 VGND VGND VDPWR VDPWR sky130_fd_sc_hd__fill_2
XFILLER_2_234 VGND VGND VDPWR VDPWR sky130_fd_sc_hd__fill_2
X_2293_ _2294_/CLK wire69/X VGND VGND VDPWR VDPWR _2301_/D sky130_fd_sc_hd__dfxtp_1
X_1313_ _1313_/A _1313_/B VGND VGND VDPWR VDPWR _1313_/Y sky130_fd_sc_hd__nand2_1
X_1244_ _1871_/A _1248_/B _1128_/B _1656_/C VGND VGND VDPWR VDPWR _1566_/C sky130_fd_sc_hd__a31oi_1
XFILLER_64_263 VGND VGND VDPWR VDPWR sky130_fd_sc_hd__fill_2
X_1175_ _1175_/A _1175_/B _1175_/C _1179_/B VGND VGND VDPWR VDPWR _1175_/Y sky130_fd_sc_hd__nor4b_1
XFILLER_32_171 VGND VGND VDPWR VDPWR sky130_fd_sc_hd__fill_2
XFILLER_70_200 VGND VGND VDPWR VDPWR sky130_fd_sc_hd__decap_3
XFILLER_46_263 VGND VGND VDPWR VDPWR sky130_fd_sc_hd__fill_1
XFILLER_61_222 VGND VGND VDPWR VDPWR sky130_fd_sc_hd__decap_3
X_1931_ _1871_/B hold138/X _1931_/S VGND VGND VDPWR VDPWR _2180_/D sky130_fd_sc_hd__mux2_1
X_1862_ _2138_/Q _1862_/B _1862_/C VGND VGND VDPWR VDPWR _1862_/Y sky130_fd_sc_hd__nand3_1
X_1793_ wire70/X _1766_/A _1766_/B _1803_/A VGND VGND VDPWR VDPWR _1794_/B sky130_fd_sc_hd__o31ai_1
Xu_sub.u_core.u_regfile.g_nibsel\[2\].g_nib\[1\].u_lo u_sub.u_core.u_regfile.g_word\[2\].g_byte\[0\].u_lat/Q1
+ u_sub.u_core.u_regfile.g_word\[2\].g_byte\[0\].u_lat/Q5 u_sub.u_core.u_regfile.g_word\[2\].g_byte\[1\].u_lat/Q1
+ u_sub.u_core.u_regfile.g_word\[2\].g_byte\[1\].u_lat/Q5 max_cap7/X max_cap4/X VGND
+ VGND VDPWR VDPWR u_sub.u_core.u_regfile.g_nibsel\[2\].g_nib\[1\].u_lo/X tg_mux4_x1
X_2276_ _2289_/CLK hold34/X VGND VGND VDPWR VDPWR _2276_/Q sky130_fd_sc_hd__dfxtp_1
X_1227_ _1570_/A _1200_/Y _1221_/Y _1179_/B _1914_/S VGND VGND VDPWR VDPWR _1227_/Y
+ sky130_fd_sc_hd__a221oi_1
X_1158_ _1187_/D _1158_/B VGND VGND VDPWR VDPWR _1189_/B sky130_fd_sc_hd__nor2_1
XFILLER_52_211 VGND VGND VDPWR VDPWR sky130_fd_sc_hd__decap_3
XTAP_TAPCELL_ROW_54_228 VGND VDPWR sky130_fd_sc_hd__tapvpwrvgnd_1
X_1089_ _1137_/A _1182_/A _1200_/A VGND VGND VDPWR VDPWR _1135_/B sky130_fd_sc_hd__nand3b_1
Xclkbuf_0_u_sub.u_timer.g_cmp\[0\].g clkbuf_0_u_sub.u_timer.g_cmp\[0\].g/A VGND VGND
+ VDPWR VDPWR clkbuf_0_u_sub.u_timer.g_cmp\[0\].g/X sky130_fd_sc_hd__clkbuf_2
X_2130_ clkload5/A hold47/X VGND VGND VDPWR VDPWR _2130_/Q sky130_fd_sc_hd__dfxtp_1
X_2061_ _2208_/Q _2088_/A _2123_/A VGND VGND VDPWR VDPWR _2061_/Y sky130_fd_sc_hd__o21ai_1
XFILLER_34_211 VGND VGND VDPWR VDPWR sky130_fd_sc_hd__fill_1
X_1914_ _1914_/A0 _1914_/A1 _1914_/S VGND VGND VDPWR VDPWR _1914_/X sky130_fd_sc_hd__mux2_1
X_1845_ _1621_/Y _1658_/B _1844_/Y VGND VGND VDPWR VDPWR _2164_/D sky130_fd_sc_hd__a21oi_1
X_1776_ _1776_/A _1779_/B VGND VGND VDPWR VDPWR _1777_/C sky130_fd_sc_hd__nor2_1
XFILLER_25_200 VGND VGND VDPWR VDPWR sky130_fd_sc_hd__decap_3
X_2259_ _2274_/CLK hold41/X VGND VGND VDPWR VDPWR _2259_/Q sky130_fd_sc_hd__dfxtp_1
XFILLER_40_214 VGND VGND VDPWR VDPWR sky130_fd_sc_hd__fill_1
XTAP_TAPCELL_ROW_73_323 VGND VDPWR sky130_fd_sc_hd__tapvpwrvgnd_1
X_1630_ wire85/A _1630_/B VGND VGND VDPWR VDPWR _1631_/B sky130_fd_sc_hd__xnor2_1
X_1561_ _1561_/A _1561_/B _1561_/C VGND VGND VDPWR VDPWR _2231_/D sky130_fd_sc_hd__nand3_1
X_1492_ _1690_/A _1990_/A VGND VGND VDPWR VDPWR _1494_/A sky130_fd_sc_hd__nand2_1
XFILLER_39_336 VGND VGND VDPWR VDPWR sky130_fd_sc_hd__decap_3
XFILLER_66_166 VGND VGND VDPWR VDPWR sky130_fd_sc_hd__decap_3
X_2113_ ui_in[0] _2291_/D VGND VGND VDPWR VDPWR _2223_/D sky130_fd_sc_hd__nand2b_1
X_2044_ _2197_/D _2044_/B VGND VGND VDPWR VDPWR _2046_/A sky130_fd_sc_hd__nor2_1
X_1828_ _1828_/A1 _1541_/B _1191_/A VGND VGND VDPWR VDPWR _1830_/A sky130_fd_sc_hd__a21oi_1
X_1759_ _2294_/D _1762_/B VGND VGND VDPWR VDPWR _1760_/B sky130_fd_sc_hd__nor2_1
XFILLER_57_122 VGND VGND VDPWR VDPWR sky130_fd_sc_hd__decap_3
XFILLER_57_155 VGND VGND VDPWR VDPWR sky130_fd_sc_hd__decap_3
XFILLER_57_177 VGND VGND VDPWR VDPWR sky130_fd_sc_hd__decap_3
XFILLER_9_207 VGND VGND VDPWR VDPWR sky130_fd_sc_hd__decap_3
XFILLER_48_100 VGND VGND VDPWR VDPWR sky130_fd_sc_hd__decap_3
XFILLER_48_166 VGND VGND VDPWR VDPWR sky130_fd_sc_hd__fill_1
XFILLER_44_90 VGND VGND VDPWR VDPWR sky130_fd_sc_hd__decap_3
XFILLER_71_180 VGND VGND VDPWR VDPWR sky130_fd_sc_hd__decap_3
X_1613_ _1613_/A0 _1613_/A1 ui_in[3] VGND VGND VDPWR VDPWR _2242_/D sky130_fd_sc_hd__mux2_1
X_1544_ _1564_/A _1564_/B _1564_/C VGND VGND VDPWR VDPWR _1560_/A sky130_fd_sc_hd__nor3_1
X_1475_ _1477_/A _1733_/C VGND VGND VDPWR VDPWR _1475_/Y sky130_fd_sc_hd__nor2_1
X_2027_ _2048_/C _2026_/Y _2022_/Y VGND VGND VDPWR VDPWR _2027_/Y sky130_fd_sc_hd__a21oi_1
Xu_adc VDPWR VGND u_adc/clk _1613_/A0 _1613_/A1 _2316_/A _2318_/A _1979_/B _1803_/A
+ _1748_/A _1734_/A1 _1475_/Y _1748_/A _1740_/A _1471_/Y _1473_/Y u_adc/s_axi_bresp[0]
+ u_adc/s_axi_bresp[1] _1429_/B2 _1697_/A2 _1890_/A2 _1914_/A1 _1863_/A2 _1696_/B_N
+ _1889_/A1 _1914_/A0 _1860_/A1 _1477_/Y u_adc/s_axi_rresp[0] u_adc/s_axi_rresp[1]
+ _1429_/A2 wire70/X u_adc/s_axi_wready u_adc_23/HI _1472_/Y _2319_/A _2317_/A _2241_/Q
+ ua[0] top
XFILLER_45_125 VGND VGND VDPWR VDPWR sky130_fd_sc_hd__decap_3
XFILLER_41_320 VGND VGND VDPWR VDPWR sky130_fd_sc_hd__decap_3
X_1260_ _2153_/Q _1829_/B VGND VGND VDPWR VDPWR _1260_/Y sky130_fd_sc_hd__nor2_1
X_1191_ _1191_/A _1191_/B VGND VGND VDPWR VDPWR _1615_/C sky130_fd_sc_hd__nand2_1
XFILLER_59_206 VGND VGND VDPWR VDPWR sky130_fd_sc_hd__fill_1
XFILLER_59_217 VGND VGND VDPWR VDPWR sky130_fd_sc_hd__fill_1
XFILLER_59_228 VGND VGND VDPWR VDPWR sky130_fd_sc_hd__fill_1
X_1527_ _1527_/A _1564_/B VGND VGND VDPWR VDPWR _1531_/A sky130_fd_sc_hd__nand2_1
XFILLER_59_239 VGND VGND VDPWR VDPWR sky130_fd_sc_hd__decap_3
Xu_sub.u_core.u_regfile.g_nibsel\[3\].g_nib\[3\].u_m2 u_sub.u_core.u_regfile.g_nibsel\[3\].g_nib\[3\].u_lo/X
+ u_sub.u_core.u_regfile.g_nibsel\[3\].g_nib\[3\].u_hi/X wire76/X VGND VGND VDPWR
+ VDPWR u_sub.u_core.u_regfile.g_port\[3\].u_b/A2 sky130_fd_sc_hd__mux2_1
X_1458_ _1231_/B _1453_/B _1681_/A VGND VGND VDPWR VDPWR _1460_/B sky130_fd_sc_hd__o21ai_1
X_1389_ _1389_/A _1833_/A _1389_/C VGND VGND VDPWR VDPWR _1389_/Y sky130_fd_sc_hd__nor3_1
XFILLER_35_26 VGND VGND VDPWR VDPWR sky130_fd_sc_hd__decap_3
XFILLER_35_59 VGND VGND VDPWR VDPWR sky130_fd_sc_hd__decap_3
XTAP_TAPCELL_ROW_14_2_2_142 VGND VDPWR sky130_fd_sc_hd__tapvpwrvgnd_1
XFILLER_37_4 VGND VGND VDPWR VDPWR sky130_fd_sc_hd__decap_3
XFILLER_41_91 VGND VGND VDPWR VDPWR sky130_fd_sc_hd__fill_1
XPHY_EDGE_ROW_47_Left_106 VGND VDPWR sky130_fd_sc_hd__tapvpwrvgnd_1
XPHY_EDGE_ROW_56_Left_115 VGND VDPWR sky130_fd_sc_hd__tapvpwrvgnd_1
X_2292_ _2295_/CLK wire70/X VGND VGND VDPWR VDPWR _2300_/D sky130_fd_sc_hd__dfxtp_1
X_1312_ _1313_/A _1313_/B VGND VGND VDPWR VDPWR _1312_/Y sky130_fd_sc_hd__nor2_1
X_1243_ _1615_/B _1243_/B VGND VGND VDPWR VDPWR _1656_/C sky130_fd_sc_hd__nor2_1
X_1174_ _1173_/A _1082_/X _1172_/A VGND VGND VDPWR VDPWR _1174_/X sky130_fd_sc_hd__a21o_1
XFILLER_32_161 VGND VGND VDPWR VDPWR sky130_fd_sc_hd__decap_3
XFILLER_64_253 VGND VGND VDPWR VDPWR sky130_fd_sc_hd__fill_1
XPHY_EDGE_ROW_65_Left_124 VGND VDPWR sky130_fd_sc_hd__tapvpwrvgnd_1
XFILLER_47_209 VGND VGND VDPWR VDPWR sky130_fd_sc_hd__decap_3
Xclkbuf_1_1__f_u_sub.u_core.addr_gclk clkbuf_0_u_sub.u_core.addr_gclk/X VGND VGND
+ VDPWR VDPWR _2274_/CLK sky130_fd_sc_hd__clkbuf_2
XFILLER_46_69 VGND VGND VDPWR VDPWR sky130_fd_sc_hd__fill_1
XFILLER_55_231 VGND VGND VDPWR VDPWR sky130_fd_sc_hd__decap_3
XFILLER_55_253 VGND VGND VDPWR VDPWR sky130_fd_sc_hd__decap_3
XPHY_EDGE_ROW_74_Left_133 VGND VDPWR sky130_fd_sc_hd__tapvpwrvgnd_1
Xu_sub.u_core.u_cg_wb_hi.u_icg clkbuf_leaf_4_clk/X _1462_/Y VGND VGND VDPWR VDPWR
+ u_sub.u_core.u_cg_wb_hi.u_icg/GCLK sky130_fd_sc_hd__dlclkp_1
XFILLER_23_194 VGND VGND VDPWR VDPWR sky130_fd_sc_hd__decap_3
XFILLER_61_201 VGND VGND VDPWR VDPWR sky130_fd_sc_hd__fill_2
XFILLER_61_245 VGND VGND VDPWR VDPWR sky130_fd_sc_hd__fill_2
X_1930_ _1923_/Y _1929_/Y _1581_/A VGND VGND VDPWR VDPWR _2175_/D sky130_fd_sc_hd__a21boi_1
XFILLER_14_194 VGND VGND VDPWR VDPWR sky130_fd_sc_hd__decap_3
X_1861_ _2185_/Q _1861_/B VGND VGND VDPWR VDPWR _1861_/Y sky130_fd_sc_hd__nand2_1
X_1792_ _2146_/Q _1792_/B VGND VGND VDPWR VDPWR _1794_/A sky130_fd_sc_hd__nor2_1
XFILLER_29_209 VGND VGND VDPWR VDPWR sky130_fd_sc_hd__decap_3
XFILLER_35_1 VGND VGND VDPWR VDPWR sky130_fd_sc_hd__decap_3
Xclkbuf_1_0__f_clk delaybuf_18_clk/X VGND VGND VDPWR VDPWR clkbuf_leaf_4_clk/A sky130_fd_sc_hd__clkbuf_2
XFILLER_37_264 VGND VGND VDPWR VDPWR sky130_fd_sc_hd__decap_3
XTAP_TAPCELL_ROW_54_229 VGND VDPWR sky130_fd_sc_hd__tapvpwrvgnd_1
X_2275_ _2290_/CLK hold33/X VGND VGND VDPWR VDPWR _2275_/Q sky130_fd_sc_hd__dfxtp_1
X_1226_ _1075_/C _1221_/A _1222_/Y _1213_/B _1848_/A VGND VGND VDPWR VDPWR _1226_/Y
+ sky130_fd_sc_hd__a221oi_1
X_1157_ _1195_/C _1175_/B _1157_/C _1175_/C VGND VGND VDPWR VDPWR _1157_/Y sky130_fd_sc_hd__nor4_1
XFILLER_32_16 VGND VGND VDPWR VDPWR sky130_fd_sc_hd__decap_3
XFILLER_32_38 VGND VGND VDPWR VDPWR sky130_fd_sc_hd__decap_3
X_1088_ _1137_/A _1182_/A _1200_/A VGND VGND VDPWR VDPWR _1236_/B sky130_fd_sc_hd__and3b_1
XFILLER_28_220 VGND VGND VDPWR VDPWR sky130_fd_sc_hd__decap_3
XFILLER_57_24 VGND VGND VDPWR VDPWR sky130_fd_sc_hd__fill_1
XFILLER_57_35 VGND VGND VDPWR VDPWR sky130_fd_sc_hd__fill_2
XFILLER_43_245 VGND VGND VDPWR VDPWR sky130_fd_sc_hd__decap_3
XFILLER_11_197 VGND VGND VDPWR VDPWR sky130_fd_sc_hd__fill_2
XFILLER_19_231 VGND VGND VDPWR VDPWR sky130_fd_sc_hd__decap_3
XFILLER_34_201 VGND VGND VDPWR VDPWR sky130_fd_sc_hd__decap_3
X_2060_ _1424_/A _2116_/B _1495_/B _2112_/B VGND VGND VDPWR VDPWR _2060_/Y sky130_fd_sc_hd__a31oi_1
X_1913_ _1432_/B _1912_/Y _1898_/B VGND VGND VDPWR VDPWR _1913_/Y sky130_fd_sc_hd__o21ai_1
X_1844_ _2164_/Q _1844_/B VGND VGND VDPWR VDPWR _1844_/Y sky130_fd_sc_hd__nor2_1
X_1775_ _2150_/Q _2149_/Q _2141_/Q _2140_/Q VGND VGND VDPWR VDPWR _1779_/B sky130_fd_sc_hd__and4_1
X_2258_ _2258_/CLK _2258_/D _2123_/A VGND VGND VDPWR VDPWR hold59/A sky130_fd_sc_hd__dfrtp_1
X_2189_ clkload5/A _2189_/D VGND VGND VDPWR VDPWR _2189_/Q sky130_fd_sc_hd__dfxtp_1
X_1209_ _1209_/A _1376_/C _1211_/A VGND VGND VDPWR VDPWR _1211_/B sky130_fd_sc_hd__nand3_1
XTAP_TAPCELL_ROW_50_210 VGND VDPWR sky130_fd_sc_hd__tapvpwrvgnd_1
XTAP_TAPCELL_ROW_73_324 VGND VDPWR sky130_fd_sc_hd__tapvpwrvgnd_1
XFILLER_69_7 VGND VGND VDPWR VDPWR sky130_fd_sc_hd__decap_3
XPHY_EDGE_ROW_39_2_2_Right_58 VGND VDPWR sky130_fd_sc_hd__tapvpwrvgnd_1
X_1560_ _1560_/A _1560_/B _1560_/C _1564_/D VGND VGND VDPWR VDPWR _1561_/C sky130_fd_sc_hd__nand4_1
XFILLER_66_134 VGND VGND VDPWR VDPWR sky130_fd_sc_hd__fill_2
X_2112_ _2112_/A _2112_/B _1495_/B _2123_/A VGND VGND VDPWR VDPWR _2222_/D sky130_fd_sc_hd__nor4bb_1
X_1491_ hold41/A hold61/A _2034_/S VGND VGND VDPWR VDPWR _1990_/A sky130_fd_sc_hd__mux2_1
XFILLER_66_178 VGND VGND VDPWR VDPWR sky130_fd_sc_hd__decap_3
X_2043_ _2197_/D _2006_/X _2042_/Y _2004_/B VGND VGND VDPWR VDPWR _2202_/D sky130_fd_sc_hd__o211ai_1
X_1827_ _2230_/Q _1811_/B _1826_/Y VGND VGND VDPWR VDPWR _2158_/D sky130_fd_sc_hd__o21ai_1
X_1758_ _2136_/Q wire71/X _2123_/A VGND VGND VDPWR VDPWR _1760_/A sky130_fd_sc_hd__o21ai_1
X_1689_ _2076_/A _1914_/S _1915_/B _1687_/Y _1688_/Y VGND VGND VDPWR VDPWR _1689_/X
+ sky130_fd_sc_hd__o32a_1
XFILLER_57_145 VGND VGND VDPWR VDPWR sky130_fd_sc_hd__decap_3
XFILLER_57_189 VGND VGND VDPWR VDPWR sky130_fd_sc_hd__decap_3
XFILLER_13_204 VGND VGND VDPWR VDPWR sky130_fd_sc_hd__decap_3
Xdelaybuf_18_clk delaybuf_18_clk/A VGND VGND VDPWR VDPWR delaybuf_18_clk/X sky130_fd_sc_hd__clkbuf_2
XFILLER_36_318 VGND VGND VDPWR VDPWR sky130_fd_sc_hd__fill_2
XFILLER_71_192 VGND VGND VDPWR VDPWR sky130_fd_sc_hd__decap_3
XFILLER_67_4 VGND VGND VDPWR VDPWR sky130_fd_sc_hd__decap_3
X_1612_ _1914_/S _1612_/B VGND VGND VDPWR VDPWR _1612_/Y sky130_fd_sc_hd__nor2_1
X_1543_ _2229_/Q _1532_/B _2236_/Q VGND VGND VDPWR VDPWR _1547_/A sky130_fd_sc_hd__o21ai_1
X_1474_ _2131_/Q _2117_/A _2116_/A _1730_/C VGND VGND VDPWR VDPWR _1733_/C sky130_fd_sc_hd__nand4b_1
XFILLER_39_112 VGND VGND VDPWR VDPWR sky130_fd_sc_hd__decap_3
XFILLER_62_170 VGND VGND VDPWR VDPWR sky130_fd_sc_hd__decap_3
X_2026_ _2203_/Q _2024_/Y _2025_/Y VGND VGND VDPWR VDPWR _2026_/Y sky130_fd_sc_hd__a21oi_1
XFILLER_49_47 VGND VGND VDPWR VDPWR sky130_fd_sc_hd__fill_1
XFILLER_65_35 VGND VGND VDPWR VDPWR sky130_fd_sc_hd__decap_3
XFILLER_41_310 VGND VGND VDPWR VDPWR sky130_fd_sc_hd__fill_2
XFILLER_53_192 VGND VGND VDPWR VDPWR sky130_fd_sc_hd__fill_1
Xu_sub.u_core.u_regfile.g_nibsel\[4\].g_nib\[1\].u_m2 u_sub.u_core.u_regfile.g_nibsel\[4\].g_nib\[1\].u_lo/X
+ u_sub.u_core.u_regfile.g_nibsel\[4\].g_nib\[1\].u_hi/X max_cap1/X VGND VGND VDPWR
+ VDPWR u_sub.u_core.u_regfile.g_port\[1\].u_b/A3 sky130_fd_sc_hd__mux2_1
XFILLER_5_211 VGND VGND VDPWR VDPWR sky130_fd_sc_hd__fill_1
XFILLER_5_233 VGND VGND VDPWR VDPWR sky130_fd_sc_hd__decap_3
Xu_sub.u_core.u_regfile.g_word\[2\].g_byte\[1\].u_cg.u_icg clkbuf_leaf_1_clk/X _1595_/X
+ VGND VGND VDPWR VDPWR u_sub.u_core.u_regfile.g_word\[2\].g_byte\[1\].u_lat/GATE
+ sky130_fd_sc_hd__dlclkp_1
X_1190_ _1480_/B _1191_/A VGND VGND VDPWR VDPWR _1454_/B sky130_fd_sc_hd__nor2b_1
XFILLER_36_137 VGND VGND VDPWR VDPWR sky130_fd_sc_hd__decap_3
XFILLER_44_170 VGND VGND VDPWR VDPWR sky130_fd_sc_hd__decap_3
XFILLER_51_129 VGND VGND VDPWR VDPWR sky130_fd_sc_hd__fill_1
XPHY_EDGE_ROW_23_2_2_Right_42 VGND VDPWR sky130_fd_sc_hd__tapvpwrvgnd_1
XTAP_TAPCELL_ROW_46_187 VGND VDPWR sky130_fd_sc_hd__tapvpwrvgnd_1
XFILLER_65_1 VGND VGND VDPWR VDPWR sky130_fd_sc_hd__decap_3
XPHY_EDGE_ROW_15_2_2_Left_4 VGND VDPWR sky130_fd_sc_hd__tapvpwrvgnd_1
X_1526_ _2152_/Q _1393_/B _1177_/Y _1541_/C VGND VGND VDPWR VDPWR _1564_/B sky130_fd_sc_hd__o211ai_1
X_1457_ _2230_/Q _1683_/A VGND VGND VDPWR VDPWR _1907_/A sky130_fd_sc_hd__or2_1
X_1388_ _1833_/A _1833_/B VGND VGND VDPWR VDPWR _1388_/Y sky130_fd_sc_hd__xnor2_1
X_2009_ _2034_/S hold43/A VGND VGND VDPWR VDPWR _2009_/Y sky130_fd_sc_hd__nor2b_1
XFILLER_2_225 VGND VGND VDPWR VDPWR sky130_fd_sc_hd__decap_3
X_2291_ _2291_/CLK _2291_/D VGND VGND VDPWR VDPWR _2312_/A sky130_fd_sc_hd__dfxtp_1
X_1311_ _1311_/A _1311_/B VGND VGND VDPWR VDPWR _1870_/A sky130_fd_sc_hd__xnor2_1
X_1242_ _1191_/A _1541_/B _1192_/Y VGND VGND VDPWR VDPWR _1243_/B sky130_fd_sc_hd__a21oi_1
X_1173_ _1173_/A _1177_/A VGND VGND VDPWR VDPWR _1393_/B sky130_fd_sc_hd__nand2_1
XFILLER_32_195 VGND VGND VDPWR VDPWR sky130_fd_sc_hd__decap_3
XFILLER_64_298 VGND VGND VDPWR VDPWR sky130_fd_sc_hd__fill_2
X_1509_ _1507_/Y _1508_/Y _2156_/Q VGND VGND VDPWR VDPWR _1512_/A sky130_fd_sc_hd__a21oi_1
XFILLER_70_257 VGND VGND VDPWR VDPWR sky130_fd_sc_hd__decap_3
XTAP_TAPCELL_ROW_65_282 VGND VDPWR sky130_fd_sc_hd__tapvpwrvgnd_1
Xmax_cap16 _2123_/A VGND VGND VDPWR VDPWR _1803_/A sky130_fd_sc_hd__buf_12
XFILLER_62_47 VGND VGND VDPWR VDPWR sky130_fd_sc_hd__decap_3
XFILLER_62_69 VGND VGND VDPWR VDPWR sky130_fd_sc_hd__fill_2
XTAP_TAPCELL_ROW_18_2_2_144 VGND VDPWR sky130_fd_sc_hd__tapvpwrvgnd_1
XFILLER_61_213 VGND VGND VDPWR VDPWR sky130_fd_sc_hd__decap_3
X_1860_ _1860_/A1 wire81/X _1914_/S VGND VGND VDPWR VDPWR _1860_/Y sky130_fd_sc_hd__a21oi_1
X_1791_ _2123_/A _1791_/B VGND VGND VDPWR VDPWR _2145_/D sky130_fd_sc_hd__and2_1
XTAP_TAPCELL_ROW_79_352 VGND VDPWR sky130_fd_sc_hd__tapvpwrvgnd_1
X_2274_ _2274_/CLK _2274_/D VGND VGND VDPWR VDPWR hold49/A sky130_fd_sc_hd__dfxtp_1
XFILLER_37_210 VGND VGND VDPWR VDPWR sky130_fd_sc_hd__decap_3
XFILLER_52_202 VGND VGND VDPWR VDPWR sky130_fd_sc_hd__fill_2
X_1087_ _1137_/A _1182_/A VGND VGND VDPWR VDPWR _1168_/C sky130_fd_sc_hd__nand2b_1
X_1225_ _1211_/B _1223_/Y _1224_/Y _1638_/A _1627_/A VGND VGND VDPWR VDPWR _1225_/X
+ sky130_fd_sc_hd__a2111o_1
X_1156_ _1195_/A _1156_/B _1209_/A VGND VGND VDPWR VDPWR _1175_/C sky130_fd_sc_hd__or3_1
XFILLER_32_28 VGND VGND VDPWR VDPWR sky130_fd_sc_hd__decap_3
X_1989_ _2204_/Q _1989_/B VGND VGND VDPWR VDPWR _1990_/B sky130_fd_sc_hd__nand2b_1
XFILLER_28_232 VGND VGND VDPWR VDPWR sky130_fd_sc_hd__decap_3
XFILLER_19_210 VGND VGND VDPWR VDPWR sky130_fd_sc_hd__decap_3
Xu_sub.u_core.u_regfile.g_word\[3\].g_byte\[0\].u_lat wire103/X wire101/X wire100/X
+ wire97/X wire95/X max_cap93/X max_cap91/X max_cap89/X u_sub.u_core.u_regfile.g_word\[3\].g_byte\[0\].u_lat/GATE
+ VGND VDPWR u_sub.u_core.u_regfile.g_word\[3\].g_byte\[0\].u_lat/Q0 u_sub.u_core.u_regfile.g_word\[3\].g_byte\[0\].u_lat/Q1
+ u_sub.u_core.u_regfile.g_word\[3\].g_byte\[0\].u_lat/Q2 u_sub.u_core.u_regfile.g_word\[3\].g_byte\[0\].u_lat/Q3
+ u_sub.u_core.u_regfile.g_word\[3\].g_byte\[0\].u_lat/Q4 u_sub.u_core.u_regfile.g_word\[3\].g_byte\[0\].u_lat/Q5
+ u_sub.u_core.u_regfile.g_word\[3\].g_byte\[0\].u_lat/Q6 u_sub.u_core.u_regfile.g_word\[3\].g_byte\[0\].u_lat/Q7
+ dlxtp8_x1
XFILLER_42_290 VGND VGND VDPWR VDPWR sky130_fd_sc_hd__fill_1
X_1912_ _2226_/Q _2116_/C _1911_/Y VGND VGND VDPWR VDPWR _1912_/Y sky130_fd_sc_hd__a21oi_1
X_1843_ _1621_/Y _1882_/C _1842_/Y VGND VGND VDPWR VDPWR _2163_/D sky130_fd_sc_hd__a21oi_1
Xclkbuf_leaf_6_clk delaybuf_15_clk/X VGND VGND VDPWR VDPWR delaybuf_2_clk/A sky130_fd_sc_hd__clkbuf_2
X_1774_ _2150_/Q _2149_/Q _2140_/Q _2141_/Q VGND VGND VDPWR VDPWR _1776_/A sky130_fd_sc_hd__a31oi_1
XFILLER_57_327 VGND VGND VDPWR VDPWR sky130_fd_sc_hd__fill_2
XFILLER_69_165 VGND VGND VDPWR VDPWR sky130_fd_sc_hd__decap_3
X_2257_ _2257_/CLK _2257_/D _2123_/A VGND VGND VDPWR VDPWR hold54/A sky130_fd_sc_hd__dfrtp_1
X_1208_ _1208_/A _1208_/B _1210_/A VGND VGND VDPWR VDPWR _1367_/C sky130_fd_sc_hd__nor3_1
XFILLER_43_49 VGND VGND VDPWR VDPWR sky130_fd_sc_hd__decap_3
XTAP_TAPCELL_ROW_50_211 VGND VDPWR sky130_fd_sc_hd__tapvpwrvgnd_1
X_2188_ clkload6/A _2188_/D VGND VGND VDPWR VDPWR _2188_/Q sky130_fd_sc_hd__dfxtp_1
X_1139_ _1214_/C _1643_/A _1168_/B VGND VGND VDPWR VDPWR _1141_/D sky130_fd_sc_hd__a21oi_1
XTAP_TAPCELL_ROW_73_325 VGND VDPWR sky130_fd_sc_hd__tapvpwrvgnd_1
XFILLER_31_216 VGND VGND VDPWR VDPWR sky130_fd_sc_hd__fill_1
X_1490_ _2197_/D VGND VGND VDPWR VDPWR _2053_/B sky130_fd_sc_hd__inv_1
XFILLER_54_308 VGND VGND VDPWR VDPWR sky130_fd_sc_hd__fill_2
XFILLER_66_146 VGND VGND VDPWR VDPWR sky130_fd_sc_hd__fill_2
XFILLER_66_157 VGND VGND VDPWR VDPWR sky130_fd_sc_hd__decap_3
Xu_sub.u_core.u_regfile.g_nibsel\[4\].g_nib\[3\].u_hi u_sub.u_core.u_regfile.g_word\[4\].g_byte\[2\].u_lat/Q3
+ u_sub.u_core.u_regfile.g_word\[4\].g_byte\[2\].u_lat/Q7 u_sub.u_core.u_regfile.g_word\[4\].g_byte\[3\].u_lat/Q3
+ u_sub.u_core.u_regfile.g_word\[4\].g_byte\[3\].u_lat/Q7 max_cap7/X _1632_/Y VGND
+ VGND VDPWR VDPWR u_sub.u_core.u_regfile.g_nibsel\[4\].g_nib\[3\].u_hi/X tg_mux4_x1
X_2111_ _2111_/A _2111_/B VGND VGND VDPWR VDPWR _2221_/D sky130_fd_sc_hd__nor2_1
X_2042_ _2310_/A _2313_/A _2291_/D _2042_/D VGND VGND VDPWR VDPWR _2042_/Y sky130_fd_sc_hd__nand4_1
X_1826_ _2156_/Q _1826_/B _1826_/C VGND VGND VDPWR VDPWR _1826_/Y sky130_fd_sc_hd__nand3_1
Xmax_cap120 _1648_/A0 VGND VGND VDPWR VDPWR _1179_/B sky130_fd_sc_hd__clkbuf_4
X_1757_ _1757_/A _1757_/B VGND VGND VDPWR VDPWR _2135_/D sky130_fd_sc_hd__nor2_1
X_1688_ _2208_/Q _1915_/B _1914_/S VGND VGND VDPWR VDPWR _1688_/Y sky130_fd_sc_hd__o21ai_1
X_2309_ _2310_/A VGND VGND VDPWR VDPWR uio_oe[2] sky130_fd_sc_hd__buf_2
XFILLER_48_124 VGND VGND VDPWR VDPWR sky130_fd_sc_hd__fill_2
XFILLER_48_135 VGND VGND VDPWR VDPWR sky130_fd_sc_hd__fill_1
XFILLER_71_171 VGND VGND VDPWR VDPWR sky130_fd_sc_hd__decap_3
XFILLER_44_81 VGND VGND VDPWR VDPWR sky130_fd_sc_hd__fill_1
X_1611_ _1614_/A _1612_/B VGND VGND VDPWR VDPWR _1611_/Y sky130_fd_sc_hd__nor2_1
XPHY_EDGE_ROW_44_Right_63 VGND VDPWR sky130_fd_sc_hd__tapvpwrvgnd_1
X_1542_ _1836_/B _1644_/B _2002_/A VGND VGND VDPWR VDPWR _1542_/Y sky130_fd_sc_hd__o21ai_1
X_1473_ _1795_/A _1473_/B VGND VGND VDPWR VDPWR _1473_/Y sky130_fd_sc_hd__nor2_1
X_2025_ _2203_/Q _2025_/B VGND VGND VDPWR VDPWR _2025_/Y sky130_fd_sc_hd__nor2_1
XFILLER_62_160 VGND VGND VDPWR VDPWR sky130_fd_sc_hd__fill_1
XPHY_EDGE_ROW_53_Right_72 VGND VDPWR sky130_fd_sc_hd__tapvpwrvgnd_1
X_1809_ _1833_/A _1384_/B _1386_/Y VGND VGND VDPWR VDPWR _1809_/Y sky130_fd_sc_hd__o21ai_1
XPHY_EDGE_ROW_62_Right_81 VGND VDPWR sky130_fd_sc_hd__tapvpwrvgnd_1
XFILLER_41_300 VGND VGND VDPWR VDPWR sky130_fd_sc_hd__decap_3
XFILLER_53_171 VGND VGND VDPWR VDPWR sky130_fd_sc_hd__fill_1
XPHY_EDGE_ROW_71_Right_90 VGND VDPWR sky130_fd_sc_hd__tapvpwrvgnd_1
Xclkbuf_1_1__f_u_sub.u_timer.u_cg_wd.gclk_o clkbuf_0_u_sub.u_timer.u_cg_wd.gclk_o/X
+ VGND VGND VDPWR VDPWR _2295_/CLK sky130_fd_sc_hd__clkbuf_2
XFILLER_44_193 VGND VGND VDPWR VDPWR sky130_fd_sc_hd__decap_3
XTAP_TAPCELL_ROW_46_188 VGND VDPWR sky130_fd_sc_hd__tapvpwrvgnd_1
X_1525_ _2152_/Q _1525_/B VGND VGND VDPWR VDPWR _1527_/A sky130_fd_sc_hd__or2_1
X_1456_ _2230_/Q _1683_/A VGND VGND VDPWR VDPWR _1681_/A sky130_fd_sc_hd__nor2_1
X_1387_ _1387_/A _1387_/B VGND VGND VDPWR VDPWR _1870_/C sky130_fd_sc_hd__xnor2_1
XFILLER_35_160 VGND VGND VDPWR VDPWR sky130_fd_sc_hd__fill_1
XFILLER_35_171 VGND VGND VDPWR VDPWR sky130_fd_sc_hd__decap_3
XFILLER_42_108 VGND VGND VDPWR VDPWR sky130_fd_sc_hd__decap_3
X_2008_ _2004_/Y _2007_/Y _1985_/Y VGND VGND VDPWR VDPWR _2198_/D sky130_fd_sc_hd__a21oi_1
Xclkbuf_1_1__f_u_sub.u_timer.g_cmp\[1\].g clkbuf_0_u_sub.u_timer.g_cmp\[1\].g/X VGND
+ VGND VDPWR VDPWR _2301_/GATE sky130_fd_sc_hd__clkbuf_2
XFILLER_58_252 VGND VGND VDPWR VDPWR sky130_fd_sc_hd__decap_3
Xu_sub.u_core.u_regfile.g_nibsel\[1\].g_nib\[2\].u_m2 u_sub.u_core.u_regfile.g_nibsel\[1\].g_nib\[2\].u_lo/X
+ u_sub.u_core.u_regfile.g_nibsel\[1\].g_nib\[2\].u_hi/X max_cap1/X VGND VGND VDPWR
+ VDPWR u_sub.u_core.u_regfile.g_port\[2\].u_b/A0 sky130_fd_sc_hd__mux2_1
X_2290_ _2290_/CLK _2290_/D VGND VGND VDPWR VDPWR hold31/A sky130_fd_sc_hd__dfxtp_1
X_1310_ _1308_/X _1310_/B VGND VGND VDPWR VDPWR _1311_/B sky130_fd_sc_hd__nand2b_1
X_1241_ _1241_/A _1241_/B _1241_/C _1566_/B VGND VGND VDPWR VDPWR _1269_/A sky130_fd_sc_hd__or4_1
XFILLER_49_263 VGND VGND VDPWR VDPWR sky130_fd_sc_hd__fill_1
XFILLER_64_277 VGND VGND VDPWR VDPWR sky130_fd_sc_hd__fill_1
X_1172_ _1172_/A _1172_/B _1237_/C VGND VGND VDPWR VDPWR _1177_/A sky130_fd_sc_hd__nor3_1
XFILLER_32_185 VGND VGND VDPWR VDPWR sky130_fd_sc_hd__fill_2
XFILLER_55_222 VGND VGND VDPWR VDPWR sky130_fd_sc_hd__decap_3
Xmax_cap17 hold24/X VGND VGND VDPWR VDPWR _2123_/A sky130_fd_sc_hd__buf_12
X_1508_ _2155_/Q _2231_/Q _1578_/A _1501_/Y VGND VGND VDPWR VDPWR _1508_/Y sky130_fd_sc_hd__o211ai_1
X_1439_ _1430_/Y _1435_/Y _1919_/A _1616_/A _2116_/A VGND VGND VDPWR VDPWR wire77/A
+ sky130_fd_sc_hd__o41ai_1
XFILLER_70_203 VGND VGND VDPWR VDPWR sky130_fd_sc_hd__fill_1
XTAP_TAPCELL_ROW_65_283 VGND VDPWR sky130_fd_sc_hd__tapvpwrvgnd_1
XFILLER_61_225 VGND VGND VDPWR VDPWR sky130_fd_sc_hd__decap_3
X_1790_ _2145_/Q _1789_/C _1789_/Y VGND VGND VDPWR VDPWR _1791_/B sky130_fd_sc_hd__o21ai_1
XTAP_TAPCELL_ROW_79_353 VGND VDPWR sky130_fd_sc_hd__tapvpwrvgnd_1
X_2273_ _2273_/CLK _2273_/D VGND VGND VDPWR VDPWR hold42/A sky130_fd_sc_hd__dfxtp_1
X_1224_ _1175_/A _1376_/C _1914_/S VGND VGND VDPWR VDPWR _1224_/Y sky130_fd_sc_hd__a21oi_1
XFILLER_37_255 VGND VGND VDPWR VDPWR sky130_fd_sc_hd__decap_3
XFILLER_52_214 VGND VGND VDPWR VDPWR sky130_fd_sc_hd__decap_3
X_1086_ _2232_/Q _1829_/A VGND VGND VDPWR VDPWR _1364_/A sky130_fd_sc_hd__nand2b_1
X_1155_ _1175_/B _1157_/C VGND VGND VDPWR VDPWR _1155_/Y sky130_fd_sc_hd__nor2_1
X_1988_ _2204_/Q _2015_/B VGND VGND VDPWR VDPWR _2048_/C sky130_fd_sc_hd__nor2_1
XFILLER_28_211 VGND VGND VDPWR VDPWR sky130_fd_sc_hd__decap_3
Xwire92 wire92/A VGND VGND VDPWR VDPWR wire92/X sky130_fd_sc_hd__buf_6
Xwire81 wire81/A VGND VGND VDPWR VDPWR wire81/X sky130_fd_sc_hd__buf_4
Xwire70 wire70/A VGND VGND VDPWR VDPWR wire70/X sky130_fd_sc_hd__buf_8
XFILLER_11_188 VGND VGND VDPWR VDPWR sky130_fd_sc_hd__fill_2
XFILLER_19_200 VGND VGND VDPWR VDPWR sky130_fd_sc_hd__decap_3
XFILLER_47_92 VGND VGND VDPWR VDPWR sky130_fd_sc_hd__decap_3
X_1911_ _1499_/C _1915_/B _1909_/Y _1910_/Y _1965_/C VGND VGND VDPWR VDPWR _1911_/Y
+ sky130_fd_sc_hd__o32ai_1
X_1842_ _2163_/Q _1842_/B VGND VGND VDPWR VDPWR _1842_/Y sky130_fd_sc_hd__nor2_1
X_1773_ _1803_/A _1789_/B _1773_/C VGND VGND VDPWR VDPWR _2140_/D sky130_fd_sc_hd__and3_1
XFILLER_25_203 VGND VGND VDPWR VDPWR sky130_fd_sc_hd__decap_3
X_2256_ _2257_/CLK _2256_/D _2291_/D VGND VGND VDPWR VDPWR hold62/A sky130_fd_sc_hd__dfrtp_1
X_2187_ clkload5/A _2187_/D VGND VGND VDPWR VDPWR _2187_/Q sky130_fd_sc_hd__dfxtp_1
X_1207_ _1209_/A _1211_/A VGND VGND VDPWR VDPWR _1207_/Y sky130_fd_sc_hd__nor2_1
X_1069_ _1158_/B _1069_/B _1069_/C _1069_/D VGND VGND VDPWR VDPWR _1069_/Y sky130_fd_sc_hd__nor4_1
X_1138_ _1168_/B _1643_/A VGND VGND VDPWR VDPWR _1408_/A sky130_fd_sc_hd__or2_1
XTAP_TAPCELL_ROW_73_326 VGND VDPWR sky130_fd_sc_hd__tapvpwrvgnd_1
XFILLER_39_339 VGND VGND VDPWR VDPWR sky130_fd_sc_hd__decap_3
XFILLER_66_169 VGND VGND VDPWR VDPWR sky130_fd_sc_hd__decap_3
X_2110_ hold24/A _2110_/B VGND VGND VDPWR VDPWR _2111_/B sky130_fd_sc_hd__nand2_1
X_2041_ _2041_/A _2041_/B VGND VGND VDPWR VDPWR _2054_/A sky130_fd_sc_hd__nor2_1
Xmax_cap110 _1614_/A VGND VGND VDPWR VDPWR _1848_/A sky130_fd_sc_hd__buf_6
Xmax_cap121 _2229_/Q VGND VGND VDPWR VDPWR _1848_/B sky130_fd_sc_hd__buf_6
X_1825_ _1538_/A _1824_/B _1823_/X _1824_/Y VGND VGND VDPWR VDPWR _2157_/D sky130_fd_sc_hd__o31ai_1
X_1756_ wire69/X _1762_/B VGND VGND VDPWR VDPWR _1757_/B sky130_fd_sc_hd__nor2_1
XFILLER_57_125 VGND VGND VDPWR VDPWR sky130_fd_sc_hd__decap_3
X_2308_ _2310_/A VGND VGND VDPWR VDPWR uio_oe[1] sky130_fd_sc_hd__buf_2
X_1687_ _2216_/Q _1687_/B VGND VGND VDPWR VDPWR _1687_/Y sky130_fd_sc_hd__nor2_1
XFILLER_57_136 VGND VGND VDPWR VDPWR sky130_fd_sc_hd__decap_3
XFILLER_57_158 VGND VGND VDPWR VDPWR sky130_fd_sc_hd__decap_3
XFILLER_65_191 VGND VGND VDPWR VDPWR sky130_fd_sc_hd__decap_3
XTAP_TAPCELL_ROW_70_307 VGND VDPWR sky130_fd_sc_hd__tapvpwrvgnd_1
X_2239_ clkload9/A hold50/X rst_n VGND VGND VDPWR VDPWR hold24/A sky130_fd_sc_hd__dfrtp_1
Xu_sub.u_core.u_regfile.g_ir\[0\].u_lat wire103/A wire102/X _2174_/Q _2175_/Q _2176_/Q
+ _2177_/Q wire92/A max_cap90/X u_sub.u_core.u_regfile.g_ir\[0\].u_lat/GATE VGND VDPWR
+ _1131_/C _1131_/D _1122_/C _1122_/D _1137_/A _1182_/A _1200_/A _1570_/A dlxtp8_x1
XFILLER_48_103 VGND VGND VDPWR VDPWR sky130_fd_sc_hd__fill_1
XFILLER_44_93 VGND VGND VDPWR VDPWR sky130_fd_sc_hd__fill_2
XFILLER_71_161 VGND VGND VDPWR VDPWR sky130_fd_sc_hd__decap_3
XFILLER_71_183 VGND VGND VDPWR VDPWR sky130_fd_sc_hd__decap_3
XFILLER_8_210 VGND VGND VDPWR VDPWR sky130_fd_sc_hd__decap_3
X_1610_ _1610_/A _1610_/B _1610_/C VGND VGND VDPWR VDPWR _1610_/Y sky130_fd_sc_hd__nor3_1
XFILLER_39_103 VGND VGND VDPWR VDPWR sky130_fd_sc_hd__decap_3
X_1541_ _1541_/A _1541_/B _1541_/C VGND VGND VDPWR VDPWR _1644_/B sky130_fd_sc_hd__and3_1
X_1472_ _2133_/Q _1473_/B VGND VGND VDPWR VDPWR _1472_/Y sky130_fd_sc_hd__nor2_1
XFILLER_39_136 VGND VGND VDPWR VDPWR sky130_fd_sc_hd__decap_3
XFILLER_54_106 VGND VGND VDPWR VDPWR sky130_fd_sc_hd__fill_2
X_2024_ _2034_/S hold58/A _2023_/Y VGND VGND VDPWR VDPWR _2024_/Y sky130_fd_sc_hd__a21oi_1
XFILLER_62_183 VGND VGND VDPWR VDPWR sky130_fd_sc_hd__fill_1
X_1808_ _1848_/B _2236_/Q _1113_/Y VGND VGND VDPWR VDPWR _1931_/S sky130_fd_sc_hd__a21oi_1
X_1739_ _2150_/Q _2149_/Q _2147_/Q _1915_/B VGND VGND VDPWR VDPWR _1750_/B sky130_fd_sc_hd__nor4_1
XFILLER_53_161 VGND VGND VDPWR VDPWR sky130_fd_sc_hd__decap_3
XFILLER_29_191 VGND VGND VDPWR VDPWR sky130_fd_sc_hd__decap_3
XTAP_TAPCELL_ROW_46_189 VGND VDPWR sky130_fd_sc_hd__tapvpwrvgnd_1
X_1524_ _2152_/Q _1525_/B VGND VGND VDPWR VDPWR _1564_/A sky130_fd_sc_hd__nor2_1
XFILLER_67_242 VGND VGND VDPWR VDPWR sky130_fd_sc_hd__decap_3
XFILLER_67_275 VGND VGND VDPWR VDPWR sky130_fd_sc_hd__fill_1
Xu_sub.u_core.u_regfile.g_nibsel\[2\].g_nib\[0\].u_m2 u_sub.u_core.u_regfile.g_nibsel\[2\].g_nib\[0\].u_lo/X
+ u_sub.u_core.u_regfile.g_nibsel\[2\].g_nib\[0\].u_hi/X max_cap75/X VGND VGND VDPWR
+ VDPWR u_sub.u_core.u_regfile.g_port\[0\].u_b/A1 sky130_fd_sc_hd__mux2_1
X_1455_ _1826_/C _1455_/B VGND VGND VDPWR VDPWR _1455_/Y sky130_fd_sc_hd__nor2_1
X_1386_ _1387_/A _1387_/B VGND VGND VDPWR VDPWR _1386_/Y sky130_fd_sc_hd__nand2b_1
XFILLER_35_29 VGND VGND VDPWR VDPWR sky130_fd_sc_hd__fill_1
XFILLER_50_131 VGND VGND VDPWR VDPWR sky130_fd_sc_hd__fill_2
X_2007_ _1994_/Y _1997_/Y _2006_/X wire70/X VGND VGND VDPWR VDPWR _2007_/Y sky130_fd_sc_hd__a22oi_1
XFILLER_50_197 VGND VGND VDPWR VDPWR sky130_fd_sc_hd__fill_2
XFILLER_41_175 VGND VGND VDPWR VDPWR sky130_fd_sc_hd__decap_3
XFILLER_37_7 VGND VGND VDPWR VDPWR sky130_fd_sc_hd__decap_3
X_1240_ _1241_/A _1241_/B _1241_/C _1566_/B VGND VGND VDPWR VDPWR _1832_/A sky130_fd_sc_hd__nor4_1
X_1171_ _1202_/A _1202_/B _1199_/A _1171_/D VGND VGND VDPWR VDPWR _1198_/A sky130_fd_sc_hd__nor4_1
XFILLER_70_1 VGND VGND VDPWR VDPWR sky130_fd_sc_hd__fill_2
XTAP_TAPCELL_ROW_42_170 VGND VDPWR sky130_fd_sc_hd__tapvpwrvgnd_1
X_1507_ _2231_/Q _1507_/B VGND VGND VDPWR VDPWR _1507_/Y sky130_fd_sc_hd__nand2_1
Xmax_cap18 hold24/X VGND VGND VDPWR VDPWR _2291_/D sky130_fd_sc_hd__buf_12
X_1438_ _1914_/S _2117_/A VGND VGND VDPWR VDPWR _1616_/A sky130_fd_sc_hd__nor2_1
X_1369_ _1376_/A _1208_/B _1211_/Y _1914_/S VGND VGND VDPWR VDPWR _1369_/Y sky130_fd_sc_hd__a211oi_1
XFILLER_23_197 VGND VGND VDPWR VDPWR sky130_fd_sc_hd__fill_2
XPHY_EDGE_ROW_43_Left_102 VGND VDPWR sky130_fd_sc_hd__tapvpwrvgnd_1
XTAP_TAPCELL_ROW_65_284 VGND VDPWR sky130_fd_sc_hd__tapvpwrvgnd_1
XPHY_EDGE_ROW_52_Left_111 VGND VDPWR sky130_fd_sc_hd__tapvpwrvgnd_1
XFILLER_36_83 VGND VGND VDPWR VDPWR sky130_fd_sc_hd__decap_3
XFILLER_46_201 VGND VGND VDPWR VDPWR sky130_fd_sc_hd__decap_3
XPHY_EDGE_ROW_14_2_2_Left_3 VGND VDPWR sky130_fd_sc_hd__tapvpwrvgnd_1
XPHY_EDGE_ROW_61_Left_120 VGND VDPWR sky130_fd_sc_hd__tapvpwrvgnd_1
XTAP_TAPCELL_ROW_56_240 VGND VDPWR sky130_fd_sc_hd__tapvpwrvgnd_1
XFILLER_14_197 VGND VGND VDPWR VDPWR sky130_fd_sc_hd__decap_3
XFILLER_52_93 VGND VGND VDPWR VDPWR sky130_fd_sc_hd__fill_2
XFILLER_35_4 VGND VGND VDPWR VDPWR sky130_fd_sc_hd__decap_3
XFILLER_69_304 VGND VGND VDPWR VDPWR sky130_fd_sc_hd__fill_2
XPHY_EDGE_ROW_35_2_2_Right_54 VGND VDPWR sky130_fd_sc_hd__tapvpwrvgnd_1
XTAP_TAPCELL_ROW_79_354 VGND VDPWR sky130_fd_sc_hd__tapvpwrvgnd_1
X_2272_ _2273_/CLK _2272_/D VGND VGND VDPWR VDPWR hold39/A sky130_fd_sc_hd__dfxtp_1
X_1223_ _1874_/A1 _1221_/B _1848_/A VGND VGND VDPWR VDPWR _1223_/Y sky130_fd_sc_hd__a21oi_1
X_1154_ _1179_/B _1213_/B VGND VGND VDPWR VDPWR _1157_/C sky130_fd_sc_hd__or2_1
XFILLER_32_19 VGND VGND VDPWR VDPWR sky130_fd_sc_hd__decap_3
XFILLER_37_267 VGND VGND VDPWR VDPWR sky130_fd_sc_hd__fill_1
X_1085_ _2232_/Q _1836_/B VGND VGND VDPWR VDPWR _1248_/C sky130_fd_sc_hd__nor2_1
X_1987_ _2203_/Q _2015_/B VGND VGND VDPWR VDPWR _1987_/Y sky130_fd_sc_hd__nor2_1
Xu_sub.u_core.u_regfile.g_word\[2\].g_byte\[3\].u_lat wire103/X wire101/X max_cap99/X
+ wire97/X wire95/X max_cap93/X wire92/X max_cap89/X u_sub.u_core.u_regfile.g_word\[2\].g_byte\[3\].u_lat/GATE
+ VGND VDPWR u_sub.u_core.u_regfile.g_word\[2\].g_byte\[3\].u_lat/Q0 u_sub.u_core.u_regfile.g_word\[2\].g_byte\[3\].u_lat/Q1
+ u_sub.u_core.u_regfile.g_word\[2\].g_byte\[3\].u_lat/Q2 u_sub.u_core.u_regfile.g_word\[2\].g_byte\[3\].u_lat/Q3
+ u_sub.u_core.u_regfile.g_word\[2\].g_byte\[3\].u_lat/Q4 u_sub.u_core.u_regfile.g_word\[2\].g_byte\[3\].u_lat/Q5
+ u_sub.u_core.u_regfile.g_word\[2\].g_byte\[3\].u_lat/Q6 u_sub.u_core.u_regfile.g_word\[2\].g_byte\[3\].u_lat/Q7
+ dlxtp8_x1
XFILLER_28_223 VGND VGND VDPWR VDPWR sky130_fd_sc_hd__fill_2
XFILLER_43_237 VGND VGND VDPWR VDPWR sky130_fd_sc_hd__fill_1
XFILLER_43_248 VGND VGND VDPWR VDPWR sky130_fd_sc_hd__decap_3
Xwire71 wire71/A VGND VGND VDPWR VDPWR wire71/X sky130_fd_sc_hd__clkbuf_2
XFILLER_19_234 VGND VGND VDPWR VDPWR sky130_fd_sc_hd__fill_2
X_1910_ _2193_/Q _1476_/B _1887_/B _2226_/Q VGND VGND VDPWR VDPWR _1910_/Y sky130_fd_sc_hd__a22oi_1
X_1841_ _1621_/Y _1666_/B _1840_/Y VGND VGND VDPWR VDPWR _2162_/D sky130_fd_sc_hd__a21oi_1
X_1772_ _2140_/Q _1772_/B VGND VGND VDPWR VDPWR _1773_/C sky130_fd_sc_hd__xnor2_1
XFILLER_33_1 VGND VGND VDPWR VDPWR sky130_fd_sc_hd__decap_3
XFILLER_69_123 VGND VGND VDPWR VDPWR sky130_fd_sc_hd__fill_1
X_2255_ _2257_/CLK _2255_/D _2291_/D VGND VGND VDPWR VDPWR hold53/A sky130_fd_sc_hd__dfrtp_1
X_2186_ clkload3/A _2186_/D VGND VGND VDPWR VDPWR _2186_/Q sky130_fd_sc_hd__dfxtp_1
X_1206_ _1112_/Y _1205_/Y _1120_/Y VGND VGND VDPWR VDPWR _1206_/Y sky130_fd_sc_hd__a21oi_1
X_1137_ _1137_/A _1147_/A VGND VGND VDPWR VDPWR _1615_/B sky130_fd_sc_hd__nand2_1
X_1068_ _1179_/B _1152_/A _1175_/A _1195_/A VGND VGND VDPWR VDPWR _1069_/D sky130_fd_sc_hd__nand4b_1
XFILLER_58_92 VGND VGND VDPWR VDPWR sky130_fd_sc_hd__fill_1
XFILLER_66_115 VGND VGND VDPWR VDPWR sky130_fd_sc_hd__fill_2
XFILLER_66_137 VGND VGND VDPWR VDPWR sky130_fd_sc_hd__decap_3
Xu_sub.u_core.u_regfile.g_nibsel\[4\].g_nib\[3\].u_lo u_sub.u_core.u_regfile.g_word\[4\].g_byte\[0\].u_lat/Q3
+ u_sub.u_core.u_regfile.g_word\[4\].g_byte\[0\].u_lat/Q7 u_sub.u_core.u_regfile.g_word\[4\].g_byte\[1\].u_lat/Q3
+ u_sub.u_core.u_regfile.g_word\[4\].g_byte\[1\].u_lat/Q7 max_cap6/X max_cap3/X VGND
+ VGND VDPWR VDPWR u_sub.u_core.u_regfile.g_nibsel\[4\].g_nib\[3\].u_lo/X tg_mux4_x1
X_2040_ _2004_/A _2039_/Y _2031_/Y VGND VGND VDPWR VDPWR _2201_/D sky130_fd_sc_hd__o21ai_1
Xmax_cap111 _1077_/A VGND VGND VDPWR VDPWR _1187_/D sky130_fd_sc_hd__clkbuf_4
Xmax_cap122 _2156_/Q VGND VGND VDPWR VDPWR _1638_/A sky130_fd_sc_hd__buf_6
X_1824_ _2157_/Q _1824_/B VGND VGND VDPWR VDPWR _1824_/Y sky130_fd_sc_hd__nand2_1
X_1755_ _2135_/Q wire71/X _2123_/A VGND VGND VDPWR VDPWR _1757_/A sky130_fd_sc_hd__o21ai_1
X_1686_ uio_in[0] _1898_/B VGND VGND VDPWR VDPWR _1686_/Y sky130_fd_sc_hd__nor2_1
XFILLER_57_148 VGND VGND VDPWR VDPWR sky130_fd_sc_hd__decap_3
X_2307_ _2310_/A VGND VGND VDPWR VDPWR uio_oe[0] sky130_fd_sc_hd__buf_2
X_2238_ clkload9/A _2238_/D rst_n VGND VGND VDPWR VDPWR hold50/A sky130_fd_sc_hd__dfrtp_1
XFILLER_13_229 VGND VGND VDPWR VDPWR sky130_fd_sc_hd__decap_3
XTAP_TAPCELL_ROW_70_308 VGND VDPWR sky130_fd_sc_hd__tapvpwrvgnd_1
X_2169_ clkload4/A _2169_/D VGND VGND VDPWR VDPWR _2169_/Q sky130_fd_sc_hd__dfxtp_1
XTAP_TAPCELL_ROW_41_1_1_160 VGND VDPWR sky130_fd_sc_hd__tapvpwrvgnd_1
Xu_sub.u_core.u_regfile.g_nibsel\[2\].g_nib\[2\].u_hi u_sub.u_core.u_regfile.g_word\[2\].g_byte\[2\].u_lat/Q2
+ u_sub.u_core.u_regfile.g_word\[2\].g_byte\[2\].u_lat/Q6 u_sub.u_core.u_regfile.g_word\[2\].g_byte\[3\].u_lat/Q2
+ u_sub.u_core.u_regfile.g_word\[2\].g_byte\[3\].u_lat/Q6 max_cap7/X max_cap79/X VGND
+ VGND VDPWR VDPWR u_sub.u_core.u_regfile.g_nibsel\[2\].g_nib\[2\].u_hi/X tg_mux4_x1
XFILLER_48_115 VGND VGND VDPWR VDPWR sky130_fd_sc_hd__fill_1
XFILLER_48_148 VGND VGND VDPWR VDPWR sky130_fd_sc_hd__fill_2
XFILLER_56_181 VGND VGND VDPWR VDPWR sky130_fd_sc_hd__decap_3
Xu_sub.u_core.u_cg_pc.u_icg delaybuf_2_clk/A _1464_/Y VGND VGND VDPWR VDPWR u_sub.u_core.u_cg_pc.u_icg/GCLK
+ sky130_fd_sc_hd__dlclkp_1
XFILLER_71_140 VGND VGND VDPWR VDPWR sky130_fd_sc_hd__decap_3
XFILLER_71_195 VGND VGND VDPWR VDPWR sky130_fd_sc_hd__decap_3
XFILLER_67_7 VGND VGND VDPWR VDPWR sky130_fd_sc_hd__decap_3
X_1540_ _1716_/B _1558_/B _1539_/Y _1563_/B _2237_/Q VGND VGND VDPWR VDPWR _2237_/D
+ sky130_fd_sc_hd__a32o_1
XFILLER_39_115 VGND VGND VDPWR VDPWR sky130_fd_sc_hd__decap_3
X_1471_ _2132_/Q _1473_/B VGND VGND VDPWR VDPWR _1471_/Y sky130_fd_sc_hd__nor2_1
XFILLER_35_343 VGND VGND VDPWR VDPWR sky130_fd_sc_hd__fill_2
XFILLER_62_140 VGND VGND VDPWR VDPWR sky130_fd_sc_hd__fill_1
XFILLER_62_151 VGND VGND VDPWR VDPWR sky130_fd_sc_hd__decap_3
XFILLER_62_173 VGND VGND VDPWR VDPWR sky130_fd_sc_hd__decap_3
X_2023_ _2034_/S hold40/A VGND VGND VDPWR VDPWR _2023_/Y sky130_fd_sc_hd__nor2b_1
X_1807_ _1728_/B _1533_/B _1806_/Y VGND VGND VDPWR VDPWR _2152_/D sky130_fd_sc_hd__o21ai_1
X_1738_ _2133_/Q _2132_/Q _1741_/C VGND VGND VDPWR VDPWR _1750_/A sky130_fd_sc_hd__nor3_1
X_1669_ _1882_/B _1878_/B _1668_/Y VGND VGND VDPWR VDPWR _1669_/Y sky130_fd_sc_hd__o21ai_1
XFILLER_38_170 VGND VGND VDPWR VDPWR sky130_fd_sc_hd__fill_1
XFILLER_65_38 VGND VGND VDPWR VDPWR sky130_fd_sc_hd__fill_2
Xu_sub.u_core.u_regfile.g_ir\[0\].u_cg.u_icg clkbuf_leaf_2_clk/X _1607_/Y VGND VGND
+ VDPWR VDPWR u_sub.u_core.u_regfile.g_ir\[0\].u_lat/GATE sky130_fd_sc_hd__dlclkp_1
XFILLER_53_184 VGND VGND VDPWR VDPWR sky130_fd_sc_hd__fill_2
XFILLER_36_118 VGND VGND VDPWR VDPWR sky130_fd_sc_hd__decap_3
XFILLER_44_173 VGND VGND VDPWR VDPWR sky130_fd_sc_hd__decap_3
XFILLER_44_184 VGND VGND VDPWR VDPWR sky130_fd_sc_hd__decap_3
XFILLER_65_4 VGND VGND VDPWR VDPWR sky130_fd_sc_hd__decap_3
X_1523_ _2159_/Q _2194_/Q VGND VGND VDPWR VDPWR _1525_/B sky130_fd_sc_hd__nand2_1
X_1454_ _1541_/A _1454_/B _1541_/C VGND VGND VDPWR VDPWR _1621_/B sky130_fd_sc_hd__nand3_1
XFILLER_67_210 VGND VGND VDPWR VDPWR sky130_fd_sc_hd__decap_3
XFILLER_67_298 VGND VGND VDPWR VDPWR sky130_fd_sc_hd__fill_2
X_1385_ _1347_/Y _1350_/B _1346_/Y VGND VGND VDPWR VDPWR _1387_/B sky130_fd_sc_hd__o21ai_1
XFILLER_50_143 VGND VGND VDPWR VDPWR sky130_fd_sc_hd__fill_2
X_2006_ _2205_/Q _1989_/B _2036_/B _2041_/B VGND VGND VDPWR VDPWR _2006_/X sky130_fd_sc_hd__a31o_1
Xclkbuf_0_clk_regs clkbuf_regs_0_clk/X VGND VGND VDPWR VDPWR clkbuf_0_clk_regs/X sky130_fd_sc_hd__clkbuf_2
XFILLER_2_228 VGND VGND VDPWR VDPWR sky130_fd_sc_hd__decap_3
XFILLER_58_221 VGND VGND VDPWR VDPWR sky130_fd_sc_hd__decap_3
XFILLER_66_81 VGND VGND VDPWR VDPWR sky130_fd_sc_hd__decap_3
X_1170_ _1201_/A _1201_/B VGND VGND VDPWR VDPWR _1171_/D sky130_fd_sc_hd__nand2_1
XFILLER_32_198 VGND VGND VDPWR VDPWR sky130_fd_sc_hd__fill_2
XFILLER_63_1 VGND VGND VDPWR VDPWR sky130_fd_sc_hd__decap_3
XTAP_TAPCELL_ROW_42_171 VGND VDPWR sky130_fd_sc_hd__tapvpwrvgnd_1
X_1506_ _2157_/Q _1506_/B VGND VGND VDPWR VDPWR _1507_/B sky130_fd_sc_hd__nand2_1
X_1437_ _1495_/A _1730_/C VGND VGND VDPWR VDPWR _1919_/A sky130_fd_sc_hd__nand2_1
XFILLER_70_205 VGND VGND VDPWR VDPWR sky130_fd_sc_hd__fill_2
Xmax_cap19 _2230_/Q VGND VGND VDPWR VDPWR _2034_/S sky130_fd_sc_hd__buf_12
X_1368_ _1210_/Y _1366_/Y _1367_/Y _1295_/Y VGND VGND VDPWR VDPWR _1368_/X sky130_fd_sc_hd__a211o_1
X_1299_ _1376_/C _1299_/B VGND VGND VDPWR VDPWR _1299_/Y sky130_fd_sc_hd__nor2_1
XFILLER_62_28 VGND VGND VDPWR VDPWR sky130_fd_sc_hd__fill_2
XTAP_TAPCELL_ROW_65_285 VGND VDPWR sky130_fd_sc_hd__tapvpwrvgnd_1
XPHY_EDGE_ROW_16_2_2_Right_35 VGND VDPWR sky130_fd_sc_hd__tapvpwrvgnd_1
Xdelaybuf_1_clk u_adc/clk VGND VGND VDPWR VDPWR delaybuf_1_clk/X sky130_fd_sc_hd__clkbuf_2
XFILLER_61_216 VGND VGND VDPWR VDPWR sky130_fd_sc_hd__fill_2
XTAP_TAPCELL_ROW_56_241 VGND VDPWR sky130_fd_sc_hd__tapvpwrvgnd_1
X_2271_ _2274_/CLK _2271_/D VGND VGND VDPWR VDPWR hold46/A sky130_fd_sc_hd__dfxtp_1
XFILLER_37_213 VGND VGND VDPWR VDPWR sky130_fd_sc_hd__decap_3
XFILLER_52_205 VGND VGND VDPWR VDPWR sky130_fd_sc_hd__decap_3
XTAP_TAPCELL_ROW_79_355 VGND VDPWR sky130_fd_sc_hd__tapvpwrvgnd_1
X_1084_ _1848_/B _2231_/Q VGND VGND VDPWR VDPWR _1836_/B sky130_fd_sc_hd__nand2_1
Xu_sub.u_core.u_regfile.g_word\[1\].g_byte\[0\].u_cg.u_icg clkbuf_leaf_3_clk/X _1584_/Y
+ VGND VGND VDPWR VDPWR u_sub.u_core.u_regfile.g_word\[1\].g_byte\[0\].u_lat/GATE
+ sky130_fd_sc_hd__dlclkp_1
X_1222_ _1208_/B _1221_/A _1211_/A VGND VGND VDPWR VDPWR _1222_/Y sky130_fd_sc_hd__o21ai_1
X_1153_ _1179_/B _1213_/B VGND VGND VDPWR VDPWR _1399_/C sky130_fd_sc_hd__nor2_1
X_1986_ _1986_/A _1989_/B VGND VGND VDPWR VDPWR _1986_/Y sky130_fd_sc_hd__nand2_1
XFILLER_9_191 VGND VGND VDPWR VDPWR sky130_fd_sc_hd__fill_2
XFILLER_28_235 VGND VGND VDPWR VDPWR sky130_fd_sc_hd__fill_1
XTAP_TAPCELL_ROW_53_222 VGND VDPWR sky130_fd_sc_hd__tapvpwrvgnd_1
Xwire72 wire72/A VGND VGND VDPWR VDPWR wire72/X sky130_fd_sc_hd__clkbuf_4
XFILLER_34_205 VGND VGND VDPWR VDPWR sky130_fd_sc_hd__decap_3
XFILLER_34_216 VGND VGND VDPWR VDPWR sky130_fd_sc_hd__fill_2
XFILLER_47_83 VGND VGND VDPWR VDPWR sky130_fd_sc_hd__decap_3
XFILLER_66_319 VGND VGND VDPWR VDPWR sky130_fd_sc_hd__fill_1
XFILLER_42_271 VGND VGND VDPWR VDPWR sky130_fd_sc_hd__fill_1
XFILLER_42_282 VGND VGND VDPWR VDPWR sky130_fd_sc_hd__fill_2
X_1840_ _2162_/Q _1842_/B VGND VGND VDPWR VDPWR _1840_/Y sky130_fd_sc_hd__nor2_1
Xclkbuf_1_1__f_u_sub.u_core.pc_gclk clkbuf_0_u_sub.u_core.pc_gclk/X VGND VGND VDPWR
+ VDPWR _2258_/CLK sky130_fd_sc_hd__clkbuf_2
Xu_sub.u_core.u_cg_addr.u_icg delaybuf_2_clk/A _1466_/Y VGND VGND VDPWR VDPWR u_sub.u_core.u_cg_addr.u_icg/GCLK
+ sky130_fd_sc_hd__dlclkp_1
X_1771_ _1765_/Y _2149_/Q _2150_/Q VGND VGND VDPWR VDPWR _1772_/B sky130_fd_sc_hd__nand3b_1
XFILLER_69_168 VGND VGND VDPWR VDPWR sky130_fd_sc_hd__fill_2
X_2254_ _2258_/CLK hold59/X _2123_/A VGND VGND VDPWR VDPWR hold60/A sky130_fd_sc_hd__dfrtp_1
XFILLER_25_227 VGND VGND VDPWR VDPWR sky130_fd_sc_hd__fill_1
X_1067_ _1152_/B _1399_/A _1156_/B _1209_/A VGND VGND VDPWR VDPWR _1069_/C sky130_fd_sc_hd__or4_1
X_2185_ clkload5/A _2185_/D VGND VGND VDPWR VDPWR _2185_/Q sky130_fd_sc_hd__dfxtp_1
X_1205_ _1205_/A _1205_/B _1205_/C VGND VGND VDPWR VDPWR _1205_/Y sky130_fd_sc_hd__nand3_1
X_1136_ _1168_/B _1214_/C VGND VGND VDPWR VDPWR _1541_/A sky130_fd_sc_hd__nor2_1
XPHY_EDGE_ROW_80_Left_139 VGND VDPWR sky130_fd_sc_hd__tapvpwrvgnd_1
X_1969_ _2192_/Q _1972_/B VGND VGND VDPWR VDPWR _1971_/A sky130_fd_sc_hd__nor2_1
XFILLER_71_300 VGND VGND VDPWR VDPWR sky130_fd_sc_hd__fill_1
XFILLER_71_344 VGND VGND VDPWR VDPWR sky130_fd_sc_hd__fill_1
Xu_sub.u_core.u_regfile.g_nibsel\[3\].g_nib\[0\].u_hi u_sub.u_core.u_regfile.g_word\[3\].g_byte\[2\].u_lat/Q0
+ u_sub.u_core.u_regfile.g_word\[3\].g_byte\[2\].u_lat/Q4 u_sub.u_core.u_regfile.g_word\[3\].g_byte\[3\].u_lat/Q0
+ u_sub.u_core.u_regfile.g_word\[3\].g_byte\[3\].u_lat/Q4 _1623_/Y max_cap4/X VGND
+ VGND VDPWR VDPWR u_sub.u_core.u_regfile.g_nibsel\[3\].g_nib\[0\].u_hi/X tg_mux4_x1
XFILLER_22_219 VGND VGND VDPWR VDPWR sky130_fd_sc_hd__fill_1
X_1823_ _2157_/Q _1836_/C VGND VGND VDPWR VDPWR _1823_/X sky130_fd_sc_hd__xor2_1
Xmax_cap112 _1480_/B VGND VGND VDPWR VDPWR _1248_/B sky130_fd_sc_hd__buf_2
X_1754_ _1754_/A _1754_/B VGND VGND VDPWR VDPWR _2134_/D sky130_fd_sc_hd__nor2_1
X_1685_ _1683_/A _1683_/B _2230_/Q VGND VGND VDPWR VDPWR _1921_/A sky130_fd_sc_hd__a21oi_1
X_2237_ clkload7/A _2237_/D _2291_/D VGND VGND VDPWR VDPWR _2237_/Q sky130_fd_sc_hd__dfrtp_1
XFILLER_53_344 VGND VGND VDPWR VDPWR sky130_fd_sc_hd__fill_1
XFILLER_65_171 VGND VGND VDPWR VDPWR sky130_fd_sc_hd__fill_1
XFILLER_65_182 VGND VGND VDPWR VDPWR sky130_fd_sc_hd__decap_3
XTAP_TAPCELL_ROW_70_309 VGND VDPWR sky130_fd_sc_hd__tapvpwrvgnd_1
X_2168_ clkload4/A _2168_/D VGND VGND VDPWR VDPWR _2168_/Q sky130_fd_sc_hd__dfxtp_1
X_2099_ _2099_/A _2099_/B _2099_/C _2099_/D VGND VGND VDPWR VDPWR _2099_/Y sky130_fd_sc_hd__nor4_1
X_1119_ _1141_/A _1141_/B _1120_/C VGND VGND VDPWR VDPWR _1552_/A sky130_fd_sc_hd__nor3_1
XTAP_TAPCELL_ROW_41_1_1_161 VGND VDPWR sky130_fd_sc_hd__tapvpwrvgnd_1
XFILLER_56_160 VGND VGND VDPWR VDPWR sky130_fd_sc_hd__fill_2
XFILLER_71_152 VGND VGND VDPWR VDPWR sky130_fd_sc_hd__decap_3
XFILLER_71_174 VGND VGND VDPWR VDPWR sky130_fd_sc_hd__decap_3
X_1470_ wire81/X _1740_/C VGND VGND VDPWR VDPWR _1473_/B sky130_fd_sc_hd__nand2_1
XFILLER_47_160 VGND VGND VDPWR VDPWR sky130_fd_sc_hd__decap_3
XFILLER_47_171 VGND VGND VDPWR VDPWR sky130_fd_sc_hd__decap_3
X_2022_ _1989_/B _2036_/B _1732_/D VGND VGND VDPWR VDPWR _2022_/Y sky130_fd_sc_hd__a21oi_1
X_1806_ _1393_/B _1464_/B _1533_/B _2152_/Q VGND VGND VDPWR VDPWR _1806_/Y sky130_fd_sc_hd__o31ai_1
X_1737_ _1862_/B _1740_/C VGND VGND VDPWR VDPWR _1741_/C sky130_fd_sc_hd__nand2_1
X_1668_ _2161_/Q _1882_/B VGND VGND VDPWR VDPWR _1668_/Y sky130_fd_sc_hd__nand2_1
X_1599_ _1601_/A _1599_/B _1601_/C VGND VGND VDPWR VDPWR _1599_/X sky130_fd_sc_hd__and3_1
XFILLER_45_119 VGND VGND VDPWR VDPWR sky130_fd_sc_hd__fill_2
XFILLER_41_303 VGND VGND VDPWR VDPWR sky130_fd_sc_hd__decap_3
XFILLER_53_152 VGND VGND VDPWR VDPWR sky130_fd_sc_hd__decap_3
Xu_sub.u_core.u_regfile.g_word\[3\].g_byte\[3\].u_cg.u_icg clkload0/A _1601_/X VGND
+ VGND VDPWR VDPWR u_sub.u_core.u_regfile.g_word\[3\].g_byte\[3\].u_lat/GATE sky130_fd_sc_hd__dlclkp_1
XFILLER_44_196 VGND VGND VDPWR VDPWR sky130_fd_sc_hd__decap_3
X_1522_ _2229_/Q _1522_/B VGND VGND VDPWR VDPWR _1532_/A sky130_fd_sc_hd__nand2_1
X_1453_ _1615_/C _1453_/B VGND VGND VDPWR VDPWR _1680_/A sky130_fd_sc_hd__nor2_1
X_2005_ _2206_/Q _1999_/X _2018_/A VGND VGND VDPWR VDPWR _2041_/B sky130_fd_sc_hd__o21a_1
X_1384_ _1833_/A _1384_/B VGND VGND VDPWR VDPWR _1387_/A sky130_fd_sc_hd__xnor2_1
Xwire2 wire2/A VGND VGND VDPWR VDPWR wire2/X sky130_fd_sc_hd__buf_2
XFILLER_41_100 VGND VGND VDPWR VDPWR sky130_fd_sc_hd__fill_2
XFILLER_41_199 VGND VGND VDPWR VDPWR sky130_fd_sc_hd__fill_1
XFILLER_49_288 VGND VGND VDPWR VDPWR sky130_fd_sc_hd__fill_2
XFILLER_32_111 VGND VGND VDPWR VDPWR sky130_fd_sc_hd__decap_3
X_1505_ _2231_/Q _2235_/Q VGND VGND VDPWR VDPWR _1519_/A sky130_fd_sc_hd__nor2_1
X_1436_ _1690_/A _2116_/B VGND VGND VDPWR VDPWR _1730_/C sky130_fd_sc_hd__nand2_1
X_1367_ _1914_/S _1367_/B _1367_/C VGND VGND VDPWR VDPWR _1367_/Y sky130_fd_sc_hd__nor3_1
XFILLER_55_225 VGND VGND VDPWR VDPWR sky130_fd_sc_hd__decap_3
XFILLER_55_269 VGND VGND VDPWR VDPWR sky130_fd_sc_hd__fill_2
XTAP_TAPCELL_ROW_65_286 VGND VDPWR sky130_fd_sc_hd__tapvpwrvgnd_1
X_1298_ _1914_/S _1298_/B VGND VGND VDPWR VDPWR _1299_/B sky130_fd_sc_hd__nor2_1
XFILLER_23_188 VGND VGND VDPWR VDPWR sky130_fd_sc_hd__decap_3
XFILLER_61_228 VGND VGND VDPWR VDPWR sky130_fd_sc_hd__decap_3
XFILLER_61_239 VGND VGND VDPWR VDPWR sky130_fd_sc_hd__decap_3
XTAP_TAPCELL_ROW_79_356 VGND VDPWR sky130_fd_sc_hd__tapvpwrvgnd_1
X_2270_ _2274_/CLK hold49/X VGND VGND VDPWR VDPWR hold48/A sky130_fd_sc_hd__dfxtp_1
X_1221_ _1221_/A _1221_/B VGND VGND VDPWR VDPWR _1221_/Y sky130_fd_sc_hd__nor2_1
XFILLER_37_258 VGND VGND VDPWR VDPWR sky130_fd_sc_hd__decap_3
X_1083_ _1848_/B _2231_/Q VGND VGND VDPWR VDPWR _1829_/A sky130_fd_sc_hd__and2_1
X_1152_ _1152_/A _1152_/B _1399_/A VGND VGND VDPWR VDPWR _1175_/B sky130_fd_sc_hd__or3_1
XTAP_TAPCELL_ROW_62_267 VGND VDPWR sky130_fd_sc_hd__tapvpwrvgnd_1
X_1985_ uio_out[0] _2053_/B VGND VGND VDPWR VDPWR _1985_/Y sky130_fd_sc_hd__nor2_1
XFILLER_28_214 VGND VGND VDPWR VDPWR sky130_fd_sc_hd__decap_3
X_1419_ _2034_/S hold52/A _1418_/Y VGND VGND VDPWR VDPWR _1690_/A sky130_fd_sc_hd__o21a_1
XFILLER_43_239 VGND VGND VDPWR VDPWR sky130_fd_sc_hd__decap_3
XFILLER_51_250 VGND VGND VDPWR VDPWR sky130_fd_sc_hd__decap_3
XTAP_TAPCELL_ROW_53_223 VGND VDPWR sky130_fd_sc_hd__tapvpwrvgnd_1
Xwire95 wire95/A VGND VGND VDPWR VDPWR wire95/X sky130_fd_sc_hd__buf_6
Xwire73 wire73/A VGND VGND VDPWR VDPWR wire73/X sky130_fd_sc_hd__buf_1
XFILLER_19_203 VGND VGND VDPWR VDPWR sky130_fd_sc_hd__fill_1
XFILLER_47_95 VGND VGND VDPWR VDPWR sky130_fd_sc_hd__fill_2
XTAP_TAPCELL_ROW_76_337 VGND VDPWR sky130_fd_sc_hd__tapvpwrvgnd_1
XFILLER_42_250 VGND VGND VDPWR VDPWR sky130_fd_sc_hd__decap_3
XPHY_EDGE_ROW_69_Right_88 VGND VDPWR sky130_fd_sc_hd__tapvpwrvgnd_1
X_1770_ _2146_/Q _2138_/Q _1803_/A VGND VGND VDPWR VDPWR _2139_/D sky130_fd_sc_hd__and3_1
XFILLER_10_191 VGND VGND VDPWR VDPWR sky130_fd_sc_hd__decap_3
XPHY_EDGE_ROW_78_Right_97 VGND VDPWR sky130_fd_sc_hd__tapvpwrvgnd_1
XFILLER_69_103 VGND VGND VDPWR VDPWR sky130_fd_sc_hd__decap_3
X_2253_ _2257_/CLK hold54/X _2123_/A VGND VGND VDPWR VDPWR hold58/A sky130_fd_sc_hd__dfrtp_1
X_2184_ clkload5/A _2184_/D VGND VGND VDPWR VDPWR _2184_/Q sky130_fd_sc_hd__dfxtp_1
X_1204_ _1205_/B _1205_/C VGND VGND VDPWR VDPWR _1643_/C sky130_fd_sc_hd__nand2_1
XFILLER_25_206 VGND VGND VDPWR VDPWR sky130_fd_sc_hd__decap_3
XFILLER_33_261 VGND VGND VDPWR VDPWR sky130_fd_sc_hd__decap_3
X_1066_ _1152_/B _1152_/A VGND VGND VDPWR VDPWR _1399_/B sky130_fd_sc_hd__nor2b_1
X_1135_ _1214_/A _1135_/B _1214_/B VGND VGND VDPWR VDPWR _1276_/A sky130_fd_sc_hd__or3_1
X_1968_ _1968_/A _1968_/B VGND VGND VDPWR VDPWR _2191_/D sky130_fd_sc_hd__nor2_1
X_1899_ _1898_/B _1897_/X _1898_/Y VGND VGND VDPWR VDPWR _1899_/Y sky130_fd_sc_hd__a21oi_1
XPHY_EDGE_ROW_13_2_2_Left_2 VGND VDPWR sky130_fd_sc_hd__tapvpwrvgnd_1
XFILLER_33_86 VGND VGND VDPWR VDPWR sky130_fd_sc_hd__decap_3
XFILLER_58_83 VGND VGND VDPWR VDPWR sky130_fd_sc_hd__decap_3
XFILLER_59_191 VGND VGND VDPWR VDPWR sky130_fd_sc_hd__decap_3
X_1822_ _1822_/A _1822_/B VGND VGND VDPWR VDPWR _2156_/D sky130_fd_sc_hd__nor2_1
X_1753_ wire70/X _1762_/B VGND VGND VDPWR VDPWR _1754_/B sky130_fd_sc_hd__nor2_1
Xmax_cap113 _1081_/C VGND VGND VDPWR VDPWR _1480_/B sky130_fd_sc_hd__clkbuf_4
X_1684_ _2230_/Q _1682_/A _1683_/Y _1581_/A VGND VGND VDPWR VDPWR _1708_/B sky130_fd_sc_hd__o31ai_1
XFILLER_57_128 VGND VGND VDPWR VDPWR sky130_fd_sc_hd__decap_3
XFILLER_57_139 VGND VGND VDPWR VDPWR sky130_fd_sc_hd__decap_3
X_2236_ _2291_/CLK _2236_/D _2291_/D VGND VGND VDPWR VDPWR _2236_/Q sky130_fd_sc_hd__dfrtp_1
X_2167_ clkload4/A _2167_/D VGND VGND VDPWR VDPWR _2167_/Q sky130_fd_sc_hd__dfxtp_1
XFILLER_65_194 VGND VGND VDPWR VDPWR sky130_fd_sc_hd__decap_3
X_1049_ _1156_/B VGND VGND VDPWR VDPWR _1237_/A sky130_fd_sc_hd__inv_1
X_2098_ _2302_/Q _2098_/B VGND VGND VDPWR VDPWR _2099_/D sky130_fd_sc_hd__xnor2_1
X_1118_ _1118_/A _1236_/A _1237_/B VGND VGND VDPWR VDPWR _1635_/C sky130_fd_sc_hd__nand3_1
Xu_sub.u_core.u_regfile.g_nibsel\[2\].g_nib\[2\].u_lo u_sub.u_core.u_regfile.g_word\[2\].g_byte\[0\].u_lat/Q2
+ u_sub.u_core.u_regfile.g_word\[2\].g_byte\[0\].u_lat/Q6 u_sub.u_core.u_regfile.g_word\[2\].g_byte\[1\].u_lat/Q2
+ u_sub.u_core.u_regfile.g_word\[2\].g_byte\[1\].u_lat/Q6 max_cap7/X max_cap4/X VGND
+ VGND VDPWR VDPWR u_sub.u_core.u_regfile.g_nibsel\[2\].g_nib\[2\].u_lo/X tg_mux4_x1
XFILLER_71_131 VGND VGND VDPWR VDPWR sky130_fd_sc_hd__decap_3
XFILLER_71_164 VGND VGND VDPWR VDPWR sky130_fd_sc_hd__decap_3
XPHY_EDGE_ROW_41_1_1_Right_60 VGND VDPWR sky130_fd_sc_hd__tapvpwrvgnd_1
XFILLER_71_186 VGND VGND VDPWR VDPWR sky130_fd_sc_hd__decap_3
XFILLER_8_213 VGND VGND VDPWR VDPWR sky130_fd_sc_hd__decap_3
X_2021_ _2204_/Q _2116_/B _2044_/B VGND VGND VDPWR VDPWR _2021_/Y sky130_fd_sc_hd__nand3_1
XFILLER_62_164 VGND VGND VDPWR VDPWR sky130_fd_sc_hd__decap_3
X_1805_ _2150_/Q _1803_/B _1804_/Y VGND VGND VDPWR VDPWR _2151_/D sky130_fd_sc_hd__a21oi_1
X_1736_ _2131_/Q _1735_/Y _1730_/X VGND VGND VDPWR VDPWR _2131_/D sky130_fd_sc_hd__o21a_1
X_1667_ _2162_/Q wire85/X _1666_/Y VGND VGND VDPWR VDPWR _1878_/B sky130_fd_sc_hd__o21ai_1
X_1598_ _1601_/A _1598_/B _1601_/C VGND VGND VDPWR VDPWR _1598_/X sky130_fd_sc_hd__and3_1
XFILLER_53_164 VGND VGND VDPWR VDPWR sky130_fd_sc_hd__decap_3
XFILLER_53_175 VGND VGND VDPWR VDPWR sky130_fd_sc_hd__decap_3
X_2219_ clkload9/A _2219_/D VGND VGND VDPWR VDPWR _2219_/Q sky130_fd_sc_hd__dfxtp_1
XPHY_EDGE_ROW_30_2_2_Left_19 VGND VDPWR sky130_fd_sc_hd__tapvpwrvgnd_1
XFILLER_29_194 VGND VGND VDPWR VDPWR sky130_fd_sc_hd__decap_3
XFILLER_44_131 VGND VGND VDPWR VDPWR sky130_fd_sc_hd__fill_1
XFILLER_71_50 VGND VGND VDPWR VDPWR sky130_fd_sc_hd__decap_3
Xdelaybuf_20_clk delaybuf_20_clk/A VGND VGND VDPWR VDPWR delaybuf_21_clk/A sky130_fd_sc_hd__clkbuf_2
X_1521_ _1521_/A _1521_/B VGND VGND VDPWR VDPWR _2230_/D sky130_fd_sc_hd__nand2_1
X_1452_ _1541_/A _1541_/C VGND VGND VDPWR VDPWR _1453_/B sky130_fd_sc_hd__nand2_1
X_1383_ _1383_/A _1833_/B VGND VGND VDPWR VDPWR _1384_/B sky130_fd_sc_hd__xnor2_1
XFILLER_67_245 VGND VGND VDPWR VDPWR sky130_fd_sc_hd__fill_1
XPHY_EDGE_ROW_31_2_2_Right_50 VGND VDPWR sky130_fd_sc_hd__tapvpwrvgnd_1
X_2004_ _2004_/A _2004_/B VGND VGND VDPWR VDPWR _2004_/Y sky130_fd_sc_hd__nand2_1
XFILLER_50_112 VGND VGND VDPWR VDPWR sky130_fd_sc_hd__decap_3
X_1719_ _2243_/Q _1728_/B VGND VGND VDPWR VDPWR _1720_/B sky130_fd_sc_hd__nor2_1
XFILLER_58_267 VGND VGND VDPWR VDPWR sky130_fd_sc_hd__fill_1
Xdelaybuf_11_clk delaybuf_11_clk/A VGND VGND VDPWR VDPWR delaybuf_12_clk/A sky130_fd_sc_hd__clkbuf_2
XFILLER_41_112 VGND VGND VDPWR VDPWR sky130_fd_sc_hd__fill_2
XFILLER_41_178 VGND VGND VDPWR VDPWR sky130_fd_sc_hd__decap_3
XFILLER_41_97 VGND VGND VDPWR VDPWR sky130_fd_sc_hd__decap_3
Xu_sub.u_core.u_regfile.g_word\[1\].g_byte\[2\].u_lat wire103/A wire102/X max_cap99/X
+ wire97/A wire95/A max_cap94/X wire92/X max_cap90/X u_sub.u_core.u_regfile.g_word\[1\].g_byte\[2\].u_lat/GATE
+ VGND VDPWR u_sub.u_core.u_regfile.g_word\[1\].g_byte\[2\].u_lat/Q0 u_sub.u_core.u_regfile.g_word\[1\].g_byte\[2\].u_lat/Q1
+ u_sub.u_core.u_regfile.g_word\[1\].g_byte\[2\].u_lat/Q2 u_sub.u_core.u_regfile.g_word\[1\].g_byte\[2\].u_lat/Q3
+ u_sub.u_core.u_regfile.g_word\[1\].g_byte\[2\].u_lat/Q4 u_sub.u_core.u_regfile.g_word\[1\].g_byte\[2\].u_lat/Q5
+ u_sub.u_core.u_regfile.g_word\[1\].g_byte\[2\].u_lat/Q6 u_sub.u_core.u_regfile.g_word\[1\].g_byte\[2\].u_lat/Q7
+ dlxtp8_x1
XFILLER_32_101 VGND VGND VDPWR VDPWR sky130_fd_sc_hd__fill_1
XFILLER_32_134 VGND VGND VDPWR VDPWR sky130_fd_sc_hd__fill_2
XFILLER_32_167 VGND VGND VDPWR VDPWR sky130_fd_sc_hd__decap_3
XPHY_EDGE_ROW_50_Right_69 VGND VDPWR sky130_fd_sc_hd__tapvpwrvgnd_1
XTAP_TAPCELL_ROW_42_162 VGND VDPWR sky130_fd_sc_hd__tapvpwrvgnd_1
X_1504_ _1501_/Y _1503_/Y _2156_/Q _2157_/Q VGND VGND VDPWR VDPWR _1504_/Y sky130_fd_sc_hd__a211oi_1
X_1435_ _1433_/Y _1434_/Y _1795_/B VGND VGND VDPWR VDPWR _1435_/Y sky130_fd_sc_hd__a21oi_1
X_1366_ _1848_/A _1399_/A _1208_/B VGND VGND VDPWR VDPWR _1366_/Y sky130_fd_sc_hd__o21ai_1
X_1297_ _1209_/A _1211_/A _2155_/Q VGND VGND VDPWR VDPWR _1297_/Y sky130_fd_sc_hd__o21ai_1
XFILLER_36_86 VGND VGND VDPWR VDPWR sky130_fd_sc_hd__fill_2
XFILLER_35_7 VGND VGND VDPWR VDPWR sky130_fd_sc_hd__decap_3
X_1220_ _1638_/A _1220_/B _1220_/C _1220_/D VGND VGND VDPWR VDPWR _1220_/Y sky130_fd_sc_hd__nand4_1
X_1151_ _1339_/B _1298_/B _1376_/A _1175_/A VGND VGND VDPWR VDPWR _1195_/C sky130_fd_sc_hd__or4_1
XFILLER_37_237 VGND VGND VDPWR VDPWR sky130_fd_sc_hd__fill_1
XFILLER_60_240 VGND VGND VDPWR VDPWR sky130_fd_sc_hd__decap_3
X_1082_ _1082_/A _1082_/B _1082_/C VGND VGND VDPWR VDPWR _1082_/X sky130_fd_sc_hd__and3_1
XTAP_TAPCELL_ROW_62_268 VGND VDPWR sky130_fd_sc_hd__tapvpwrvgnd_1
X_1984_ _1527_/A _1982_/Y _1983_/Y VGND VGND VDPWR VDPWR _2196_/D sky130_fd_sc_hd__a21oi_1
X_1418_ hold55/A _2034_/S VGND VGND VDPWR VDPWR _1418_/Y sky130_fd_sc_hd__nand2b_1
X_1349_ _1311_/A _1310_/B _1308_/X VGND VGND VDPWR VDPWR _1350_/B sky130_fd_sc_hd__a21oi_1
XFILLER_51_273 VGND VGND VDPWR VDPWR sky130_fd_sc_hd__fill_2
XTAP_TAPCELL_ROW_53_224 VGND VDPWR sky130_fd_sc_hd__tapvpwrvgnd_1
Xwire85 wire85/A VGND VGND VDPWR VDPWR wire85/X sky130_fd_sc_hd__clkbuf_8
XFILLER_47_63 VGND VGND VDPWR VDPWR sky130_fd_sc_hd__fill_1
XTAP_TAPCELL_ROW_76_338 VGND VDPWR sky130_fd_sc_hd__tapvpwrvgnd_1
XFILLER_42_273 VGND VGND VDPWR VDPWR sky130_fd_sc_hd__fill_1
XFILLER_33_4 VGND VGND VDPWR VDPWR sky130_fd_sc_hd__decap_3
X_2252_ _2257_/CLK hold62/X _2123_/A VGND VGND VDPWR VDPWR hold63/A sky130_fd_sc_hd__dfrtp_1
X_2183_ clkload5/A _2183_/D VGND VGND VDPWR VDPWR _2183_/Q sky130_fd_sc_hd__dfxtp_1
X_1203_ _1205_/B _1205_/C VGND VGND VDPWR VDPWR _1541_/C sky130_fd_sc_hd__and2_1
X_1134_ _1214_/A _1135_/B _1214_/B VGND VGND VDPWR VDPWR _1147_/D sky130_fd_sc_hd__nor3_1
X_1065_ _1158_/B _1069_/B VGND VGND VDPWR VDPWR _1065_/Y sky130_fd_sc_hd__nor2_1
X_1967_ wire70/X _1965_/X _1803_/A VGND VGND VDPWR VDPWR _1968_/B sky130_fd_sc_hd__o21ai_1
X_1898_ uio_in[1] _1898_/B VGND VGND VDPWR VDPWR _1898_/Y sky130_fd_sc_hd__nor2_1
XFILLER_16_207 VGND VGND VDPWR VDPWR sky130_fd_sc_hd__fill_2
XFILLER_68_181 VGND VGND VDPWR VDPWR sky130_fd_sc_hd__fill_1
XFILLER_33_10 VGND VGND VDPWR VDPWR sky130_fd_sc_hd__decap_3
XPHY_EDGE_ROW_28_2_2_Right_47 VGND VDPWR sky130_fd_sc_hd__tapvpwrvgnd_1
XTAP_TAPCELL_ROW_40_2_2_155 VGND VDPWR sky130_fd_sc_hd__tapvpwrvgnd_1
Xu_sub.u_core.u_regfile.g_nibsel\[3\].g_nib\[0\].u_lo u_sub.u_core.u_regfile.g_word\[3\].g_byte\[0\].u_lat/Q0
+ u_sub.u_core.u_regfile.g_word\[3\].g_byte\[0\].u_lat/Q4 u_sub.u_core.u_regfile.g_word\[3\].g_byte\[1\].u_lat/Q0
+ u_sub.u_core.u_regfile.g_word\[3\].g_byte\[1\].u_lat/Q4 _1623_/Y max_cap4/X VGND
+ VGND VDPWR VDPWR u_sub.u_core.u_regfile.g_nibsel\[3\].g_nib\[0\].u_lo/X tg_mux4_x1
Xmax_cap114 _1191_/A VGND VGND VDPWR VDPWR _1874_/A1 sky130_fd_sc_hd__buf_2
X_1821_ _1826_/B _1814_/A _1814_/B _2156_/Q VGND VGND VDPWR VDPWR _1822_/B sky130_fd_sc_hd__a31oi_1
X_1752_ _2134_/Q wire71/X _2123_/A VGND VGND VDPWR VDPWR _1754_/A sky130_fd_sc_hd__o21ai_1
X_1683_ _1683_/A _1683_/B VGND VGND VDPWR VDPWR _1683_/Y sky130_fd_sc_hd__nand2_1
XFILLER_57_107 VGND VGND VDPWR VDPWR sky130_fd_sc_hd__fill_1
X_1117_ _1118_/A _1236_/A _1237_/B VGND VGND VDPWR VDPWR _1120_/C sky130_fd_sc_hd__and3_1
X_2235_ clkload7/A _2235_/D _2291_/D VGND VGND VDPWR VDPWR _2235_/Q sky130_fd_sc_hd__dfrtp_1
X_2166_ clkload4/A _2166_/D VGND VGND VDPWR VDPWR _2166_/Q sky130_fd_sc_hd__dfxtp_1
X_2097_ _2300_/Q _2097_/B VGND VGND VDPWR VDPWR _2099_/C sky130_fd_sc_hd__xnor2_1
X_1048_ _1480_/B VGND VGND VDPWR VDPWR _1191_/B sky130_fd_sc_hd__inv_1
Xclkbuf_1_0__f_u_sub.u_timer.g_cmp\[1\].g clkbuf_0_u_sub.u_timer.g_cmp\[1\].g/X VGND
+ VGND VDPWR VDPWR _2303_/GATE sky130_fd_sc_hd__clkbuf_2
XFILLER_48_129 VGND VGND VDPWR VDPWR sky130_fd_sc_hd__decap_3
Xclkbuf_1_1__f_clk clkbuf_0_clk/X VGND VGND VDPWR VDPWR delaybuf_15_clk/A sky130_fd_sc_hd__clkbuf_2
XFILLER_56_184 VGND VGND VDPWR VDPWR sky130_fd_sc_hd__decap_3
XFILLER_71_110 VGND VGND VDPWR VDPWR sky130_fd_sc_hd__decap_3
XFILLER_71_143 VGND VGND VDPWR VDPWR sky130_fd_sc_hd__decap_3
XFILLER_71_198 VGND VGND VDPWR VDPWR sky130_fd_sc_hd__decap_3
XFILLER_39_118 VGND VGND VDPWR VDPWR sky130_fd_sc_hd__fill_1
XPHY_EDGE_ROW_59_Left_118 VGND VDPWR sky130_fd_sc_hd__tapvpwrvgnd_1
X_2020_ uio_out[2] _2197_/D VGND VGND VDPWR VDPWR _2020_/Y sky130_fd_sc_hd__nand2_1
XFILLER_62_154 VGND VGND VDPWR VDPWR sky130_fd_sc_hd__decap_3
XFILLER_62_176 VGND VGND VDPWR VDPWR sky130_fd_sc_hd__decap_3
XPHY_EDGE_ROW_68_Left_127 VGND VDPWR sky130_fd_sc_hd__tapvpwrvgnd_1
X_1804_ _2151_/Q _1803_/B _1803_/A VGND VGND VDPWR VDPWR _1804_/Y sky130_fd_sc_hd__o21ai_1
X_1735_ _2121_/B _1735_/B VGND VGND VDPWR VDPWR _1735_/Y sky130_fd_sc_hd__nor2_1
X_1666_ wire85/X _1666_/B VGND VGND VDPWR VDPWR _1666_/Y sky130_fd_sc_hd__nand2_1
X_1597_ _1601_/B _1597_/B VGND VGND VDPWR VDPWR _1597_/X sky130_fd_sc_hd__and2_1
XPHY_EDGE_ROW_77_Left_136 VGND VDPWR sky130_fd_sc_hd__tapvpwrvgnd_1
X_2218_ clkload9/A _2218_/D VGND VGND VDPWR VDPWR _2218_/Q sky130_fd_sc_hd__dfxtp_1
X_2149_ clkload6/A _2149_/D VGND VGND VDPWR VDPWR _2149_/Q sky130_fd_sc_hd__dfxtp_1
XPHY_EDGE_ROW_12_2_2_Right_31 VGND VDPWR sky130_fd_sc_hd__tapvpwrvgnd_1
XFILLER_44_176 VGND VGND VDPWR VDPWR sky130_fd_sc_hd__decap_3
XFILLER_44_187 VGND VGND VDPWR VDPWR sky130_fd_sc_hd__decap_3
XFILLER_71_62 VGND VGND VDPWR VDPWR sky130_fd_sc_hd__fill_2
XFILLER_65_7 VGND VGND VDPWR VDPWR sky130_fd_sc_hd__fill_2
X_1520_ _2229_/Q _1519_/A _1558_/B _1519_/C _2228_/Q VGND VGND VDPWR VDPWR _1521_/B
+ sky130_fd_sc_hd__a41oi_1
XFILLER_67_213 VGND VGND VDPWR VDPWR sky130_fd_sc_hd__fill_2
XFILLER_67_235 VGND VGND VDPWR VDPWR sky130_fd_sc_hd__decap_3
X_1451_ _1517_/A _1451_/B VGND VGND VDPWR VDPWR _1455_/B sky130_fd_sc_hd__nor2_1
X_1382_ _1833_/B VGND VGND VDPWR VDPWR _1389_/C sky130_fd_sc_hd__inv_1
XFILLER_35_121 VGND VGND VDPWR VDPWR sky130_fd_sc_hd__decap_3
X_2003_ _2207_/Q _2015_/B _2053_/B _2002_/Y VGND VGND VDPWR VDPWR _2004_/B sky130_fd_sc_hd__o211ai_1
XFILLER_50_168 VGND VGND VDPWR VDPWR sky130_fd_sc_hd__decap_3
XTAP_TAPCELL_ROW_45_182 VGND VDPWR sky130_fd_sc_hd__tapvpwrvgnd_1
X_1718_ _2275_/Q _1727_/B VGND VGND VDPWR VDPWR _1720_/A sky130_fd_sc_hd__nor2_1
X_1649_ _1881_/C VGND VGND VDPWR VDPWR _1882_/B sky130_fd_sc_hd__inv_1
XFILLER_58_202 VGND VGND VDPWR VDPWR sky130_fd_sc_hd__fill_2
XFILLER_58_235 VGND VGND VDPWR VDPWR sky130_fd_sc_hd__decap_3
XFILLER_41_87 VGND VGND VDPWR VDPWR sky130_fd_sc_hd__fill_1
Xdelaybuf_4_clk delaybuf_4_clk/A VGND VGND VDPWR VDPWR u_fpga/clk sky130_fd_sc_hd__clkbuf_2
XFILLER_64_227 VGND VGND VDPWR VDPWR sky130_fd_sc_hd__fill_1
XFILLER_66_84 VGND VGND VDPWR VDPWR sky130_fd_sc_hd__decap_3
XTAP_TAPCELL_ROW_59_252 VGND VDPWR sky130_fd_sc_hd__tapvpwrvgnd_1
XTAP_TAPCELL_ROW_42_163 VGND VDPWR sky130_fd_sc_hd__tapvpwrvgnd_1
XFILLER_63_4 VGND VGND VDPWR VDPWR sky130_fd_sc_hd__decap_3
X_1503_ _2154_/Q _2235_/Q VGND VGND VDPWR VDPWR _1503_/Y sky130_fd_sc_hd__nand2_1
X_1434_ _2181_/Q _2147_/Q _1428_/Y VGND VGND VDPWR VDPWR _1434_/Y sky130_fd_sc_hd__o21ai_1
X_1365_ _1856_/A1 _1716_/B _1112_/Y _2246_/Q _1364_/Y VGND VGND VDPWR VDPWR _1365_/Y
+ sky130_fd_sc_hd__a221oi_1
X_1296_ _1210_/Y _1293_/Y _1294_/Y _1295_/Y VGND VGND VDPWR VDPWR _1296_/Y sky130_fd_sc_hd__a211oi_1
XFILLER_48_290 VGND VGND VDPWR VDPWR sky130_fd_sc_hd__fill_2
XFILLER_46_205 VGND VGND VDPWR VDPWR sky130_fd_sc_hd__decap_3
XFILLER_54_271 VGND VGND VDPWR VDPWR sky130_fd_sc_hd__fill_1
X_1150_ _1162_/A _1221_/B _1189_/A _1149_/Y VGND VGND VDPWR VDPWR _1202_/B sky130_fd_sc_hd__nor4bb_1
XFILLER_52_208 VGND VGND VDPWR VDPWR sky130_fd_sc_hd__decap_3
XTAP_TAPCELL_ROW_62_269 VGND VDPWR sky130_fd_sc_hd__tapvpwrvgnd_1
X_1081_ _1871_/A _1081_/B _1081_/C VGND VGND VDPWR VDPWR _1237_/C sky130_fd_sc_hd__or3_1
Xu_sub.u_core.u_regfile.g_nibsel\[4\].g_nib\[2\].u_m2 u_sub.u_core.u_regfile.g_nibsel\[4\].g_nib\[2\].u_lo/X
+ u_sub.u_core.u_regfile.g_nibsel\[4\].g_nib\[2\].u_hi/X max_cap1/X VGND VGND VDPWR
+ VDPWR u_sub.u_core.u_regfile.g_port\[2\].u_b/A3 sky130_fd_sc_hd__mux2_1
XFILLER_61_1 VGND VGND VDPWR VDPWR sky130_fd_sc_hd__decap_3
X_1983_ _2196_/Q _1527_/A _2123_/A VGND VGND VDPWR VDPWR _1983_/Y sky130_fd_sc_hd__o21ai_1
X_1417_ _1521_/A _2002_/A _1855_/B _1488_/C VGND VGND VDPWR VDPWR _1424_/A sky130_fd_sc_hd__a31oi_1
X_1348_ _1352_/A _1348_/B VGND VGND VDPWR VDPWR _1350_/A sky130_fd_sc_hd__xor2_1
X_1279_ _1393_/B _1275_/Y _1278_/Y VGND VGND VDPWR VDPWR _1279_/Y sky130_fd_sc_hd__a21oi_1
XTAP_TAPCELL_ROW_53_225 VGND VDPWR sky130_fd_sc_hd__tapvpwrvgnd_1
Xwire97 wire97/A VGND VGND VDPWR VDPWR wire97/X sky130_fd_sc_hd__buf_6
Xwire86 wire86/A VGND VGND VDPWR VDPWR wire86/X sky130_fd_sc_hd__clkbuf_2
XTAP_TAPCELL_ROW_76_339 VGND VDPWR sky130_fd_sc_hd__tapvpwrvgnd_1
XFILLER_42_230 VGND VGND VDPWR VDPWR sky130_fd_sc_hd__fill_1
XFILLER_47_86 VGND VGND VDPWR VDPWR sky130_fd_sc_hd__decap_3
X_2228__21 VGND VGND VDPWR VDPWR _2228__21/HI _2228_/D sky130_fd_sc_hd__conb_1
XFILLER_69_138 VGND VGND VDPWR VDPWR sky130_fd_sc_hd__fill_2
X_2320_ _2320_/A VGND VGND VDPWR VDPWR uo_out[7] sky130_fd_sc_hd__buf_2
X_2251_ _2258_/CLK hold53/X _2123_/A VGND VGND VDPWR VDPWR hold57/A sky130_fd_sc_hd__dfrtp_1
X_1064_ _1213_/B _1339_/B _1298_/B _1376_/A VGND VGND VDPWR VDPWR _1069_/B sky130_fd_sc_hd__or4_1
X_2182_ clkload5/A _2182_/D VGND VGND VDPWR VDPWR _2182_/Q sky130_fd_sc_hd__dfxtp_1
X_1202_ _1202_/A _1202_/B _1202_/C _1202_/D VGND VGND VDPWR VDPWR _1205_/C sky130_fd_sc_hd__nor4_1
X_1133_ _1376_/C _1211_/A VGND VGND VDPWR VDPWR _1221_/B sky130_fd_sc_hd__nand2_1
X_1966_ _2191_/Q _1972_/B VGND VGND VDPWR VDPWR _1968_/A sky130_fd_sc_hd__nor2_1
X_1897_ _1919_/A _1889_/Y _1891_/Y _1896_/Y _1432_/B VGND VGND VDPWR VDPWR _1897_/X
+ sky130_fd_sc_hd__o32a_1
XFILLER_16_219 VGND VGND VDPWR VDPWR sky130_fd_sc_hd__fill_1
XFILLER_33_66 VGND VGND VDPWR VDPWR sky130_fd_sc_hd__fill_2
XFILLER_59_171 VGND VGND VDPWR VDPWR sky130_fd_sc_hd__decap_3
XTAP_TAPCELL_ROW_72_320 VGND VDPWR sky130_fd_sc_hd__tapvpwrvgnd_1
X_1820_ _1814_/C _1836_/C _1824_/B VGND VGND VDPWR VDPWR _1822_/A sky130_fd_sc_hd__a21oi_1
Xmax_cap104 _2172_/Q VGND VGND VDPWR VDPWR wire103/A sky130_fd_sc_hd__clkbuf_8
Xmax_cap115 _1081_/B VGND VGND VDPWR VDPWR _1191_/A sky130_fd_sc_hd__clkbuf_4
X_1751_ _2138_/Q _1766_/B _1950_/B VGND VGND VDPWR VDPWR wire71/A sky130_fd_sc_hd__nor3_1
X_1682_ _1682_/A _1871_/A _2170_/Q VGND VGND VDPWR VDPWR _1683_/B sky130_fd_sc_hd__or3b_1
XFILLER_57_119 VGND VGND VDPWR VDPWR sky130_fd_sc_hd__decap_3
X_2303_ _2303_/D _2303_/GATE VGND VGND VDPWR VDPWR _2303_/Q sky130_fd_sc_hd__dlxtp_1
X_2234_ clkload7/A _2234_/D _2291_/D VGND VGND VDPWR VDPWR _2234_/Q sky130_fd_sc_hd__dfrtp_1
XFILLER_38_344 VGND VGND VDPWR VDPWR sky130_fd_sc_hd__fill_1
XFILLER_65_185 VGND VGND VDPWR VDPWR sky130_fd_sc_hd__decap_3
X_1047_ _1191_/A VGND VGND VDPWR VDPWR _1079_/A sky130_fd_sc_hd__inv_1
X_1116_ _1200_/A _1168_/B VGND VGND VDPWR VDPWR _1147_/A sky130_fd_sc_hd__nor2_1
X_2165_ clkload4/A _2165_/D VGND VGND VDPWR VDPWR _2165_/Q sky130_fd_sc_hd__dfxtp_1
X_2096_ _2297_/Q _2064_/Y _2092_/X _2093_/X _2095_/Y VGND VGND VDPWR VDPWR _2099_/B
+ sky130_fd_sc_hd__o2111ai_1
X_1949_ wire2/A _1948_/X _1803_/A VGND VGND VDPWR VDPWR _2186_/D sky130_fd_sc_hd__o21a_1
XFILLER_56_130 VGND VGND VDPWR VDPWR sky130_fd_sc_hd__decap_3
XFILLER_56_152 VGND VGND VDPWR VDPWR sky130_fd_sc_hd__decap_3
XFILLER_71_155 VGND VGND VDPWR VDPWR sky130_fd_sc_hd__decap_3
XFILLER_71_177 VGND VGND VDPWR VDPWR sky130_fd_sc_hd__decap_3
XFILLER_47_163 VGND VGND VDPWR VDPWR sky130_fd_sc_hd__decap_3
XFILLER_47_174 VGND VGND VDPWR VDPWR sky130_fd_sc_hd__decap_3
XFILLER_62_100 VGND VGND VDPWR VDPWR sky130_fd_sc_hd__decap_3
XPHY_EDGE_ROW_12_2_2_Left_1 VGND VDPWR sky130_fd_sc_hd__tapvpwrvgnd_1
XFILLER_62_199 VGND VGND VDPWR VDPWR sky130_fd_sc_hd__decap_3
X_1803_ _1803_/A _1803_/B VGND VGND VDPWR VDPWR _2150_/D sky130_fd_sc_hd__and2_1
X_1734_ _1734_/A1 wire81/X wire2/A _1733_/Y VGND VGND VDPWR VDPWR _1735_/B sky130_fd_sc_hd__a211oi_1
X_1665_ _1051_/Y _1656_/Y _1853_/D VGND VGND VDPWR VDPWR _1666_/B sky130_fd_sc_hd__mux2_1
X_1596_ _1600_/B _1597_/B VGND VGND VDPWR VDPWR _1596_/X sky130_fd_sc_hd__and2_1
X_2217_ clkload9/A _2217_/D VGND VGND VDPWR VDPWR _2217_/Q sky130_fd_sc_hd__dfxtp_1
XFILLER_53_144 VGND VGND VDPWR VDPWR sky130_fd_sc_hd__decap_3
XFILLER_53_155 VGND VGND VDPWR VDPWR sky130_fd_sc_hd__decap_3
X_2148_ clkload3/A _2148_/D VGND VGND VDPWR VDPWR _2148_/Q sky130_fd_sc_hd__dfxtp_1
X_2079_ _2213_/Q _2082_/C VGND VGND VDPWR VDPWR _2091_/B sky130_fd_sc_hd__xnor2_1
Xu_sub.u_core.u_regfile.g_word\[4\].g_byte\[0\].u_lat wire103/A wire102/X max_cap99/X
+ wire97/A wire95/A max_cap94/X wire92/X max_cap90/X u_sub.u_core.u_regfile.g_word\[4\].g_byte\[0\].u_lat/GATE
+ VGND VDPWR u_sub.u_core.u_regfile.g_word\[4\].g_byte\[0\].u_lat/Q0 u_sub.u_core.u_regfile.g_word\[4\].g_byte\[0\].u_lat/Q1
+ u_sub.u_core.u_regfile.g_word\[4\].g_byte\[0\].u_lat/Q2 u_sub.u_core.u_regfile.g_word\[4\].g_byte\[0\].u_lat/Q3
+ u_sub.u_core.u_regfile.g_word\[4\].g_byte\[0\].u_lat/Q4 u_sub.u_core.u_regfile.g_word\[4\].g_byte\[0\].u_lat/Q5
+ u_sub.u_core.u_regfile.g_word\[4\].g_byte\[0\].u_lat/Q6 u_sub.u_core.u_regfile.g_word\[4\].g_byte\[0\].u_lat/Q7
+ dlxtp8_x1
XFILLER_44_199 VGND VGND VDPWR VDPWR sky130_fd_sc_hd__decap_3
XFILLER_71_41 VGND VGND VDPWR VDPWR sky130_fd_sc_hd__decap_3
X_1450_ _1829_/B _1506_/B _1449_/X _1836_/B VGND VGND VDPWR VDPWR _1451_/B sky130_fd_sc_hd__a211o_1
X_1381_ wire67/X _1248_/C _1648_/S _1206_/Y _1380_/Y VGND VGND VDPWR VDPWR _1833_/B
+ sky130_fd_sc_hd__a32o_1
XFILLER_50_103 VGND VGND VDPWR VDPWR sky130_fd_sc_hd__decap_3
XTAP_TAPCELL_ROW_45_183 VGND VDPWR sky130_fd_sc_hd__tapvpwrvgnd_1
X_2002_ _2002_/A _2015_/B VGND VGND VDPWR VDPWR _2002_/Y sky130_fd_sc_hd__nand2_1
XFILLER_58_214 VGND VGND VDPWR VDPWR sky130_fd_sc_hd__fill_1
X_1717_ _1716_/B _1392_/Y _1716_/Y VGND VGND VDPWR VDPWR _2274_/D sky130_fd_sc_hd__a21oi_1
X_1648_ _1648_/A0 _2166_/Q _1648_/S VGND VGND VDPWR VDPWR _1881_/C sky130_fd_sc_hd__mux2_1
X_1579_ _1580_/B _1580_/C _2156_/Q VGND VGND VDPWR VDPWR _1581_/B sky130_fd_sc_hd__a21o_1
XTAP_TAPCELL_ROW_68_297 VGND VDPWR sky130_fd_sc_hd__tapvpwrvgnd_1
XFILLER_41_103 VGND VGND VDPWR VDPWR sky130_fd_sc_hd__decap_3
XFILLER_41_158 VGND VGND VDPWR VDPWR sky130_fd_sc_hd__decap_3
XFILLER_49_203 VGND VGND VDPWR VDPWR sky130_fd_sc_hd__fill_2
XFILLER_49_236 VGND VGND VDPWR VDPWR sky130_fd_sc_hd__fill_2
XTAP_TAPCELL_ROW_59_253 VGND VDPWR sky130_fd_sc_hd__tapvpwrvgnd_1
XFILLER_32_103 VGND VGND VDPWR VDPWR sky130_fd_sc_hd__fill_1
XFILLER_32_114 VGND VGND VDPWR VDPWR sky130_fd_sc_hd__decap_3
XFILLER_32_158 VGND VGND VDPWR VDPWR sky130_fd_sc_hd__decap_3
XTAP_TAPCELL_ROW_42_164 VGND VDPWR sky130_fd_sc_hd__tapvpwrvgnd_1
X_1502_ _2156_/Q _2234_/Q _2232_/Q _2236_/Q _1572_/A VGND VGND VDPWR VDPWR _1502_/Y
+ sky130_fd_sc_hd__o41ai_1
X_1433_ _2186_/Q _2148_/Q _2131_/Q _2117_/A VGND VGND VDPWR VDPWR _1433_/Y sky130_fd_sc_hd__o211ai_1
XFILLER_55_228 VGND VGND VDPWR VDPWR sky130_fd_sc_hd__decap_3
XFILLER_55_239 VGND VGND VDPWR VDPWR sky130_fd_sc_hd__decap_3
X_1364_ _1364_/A _1364_/B VGND VGND VDPWR VDPWR _1364_/Y sky130_fd_sc_hd__nor2_1
X_1295_ _1848_/A _1209_/A _1211_/A _1627_/A VGND VGND VDPWR VDPWR _1295_/Y sky130_fd_sc_hd__o31ai_1
XFILLER_31_191 VGND VGND VDPWR VDPWR sky130_fd_sc_hd__fill_2
Xu_sub.u_core.u_regfile.g_word\[4\].g_byte\[0\].u_cg.u_icg clkbuf_leaf_2_clk/X _1602_/Y
+ VGND VGND VDPWR VDPWR u_sub.u_core.u_regfile.g_word\[4\].g_byte\[0\].u_lat/GATE
+ sky130_fd_sc_hd__dlclkp_1
XFILLER_36_66 VGND VGND VDPWR VDPWR sky130_fd_sc_hd__fill_2
XFILLER_46_228 VGND VGND VDPWR VDPWR sky130_fd_sc_hd__fill_1
Xu_sub.u_core.u_regfile.g_word\[2\].g_byte\[2\].u_cg.u_icg clkbuf_leaf_1_clk/X _1596_/X
+ VGND VGND VDPWR VDPWR u_sub.u_core.u_regfile.g_word\[2\].g_byte\[2\].u_lat/GATE
+ sky130_fd_sc_hd__dlclkp_1
X_1080_ _1871_/A _1191_/A _1081_/C VGND VGND VDPWR VDPWR _1082_/C sky130_fd_sc_hd__nor3_1
X_1982_ _2226_/Q _2193_/Q _1982_/C VGND VGND VDPWR VDPWR _1982_/Y sky130_fd_sc_hd__nand3_1
XFILLER_13_191 VGND VGND VDPWR VDPWR sky130_fd_sc_hd__fill_2
X_1416_ _2025_/B _1416_/B _1416_/C VGND VGND VDPWR VDPWR _1488_/C sky130_fd_sc_hd__nand3_1
X_1347_ _1352_/A _1348_/B VGND VGND VDPWR VDPWR _1347_/Y sky130_fd_sc_hd__nor2_1
XFILLER_36_261 VGND VGND VDPWR VDPWR sky130_fd_sc_hd__decap_3
XTAP_TAPCELL_ROW_53_226 VGND VDPWR sky130_fd_sc_hd__tapvpwrvgnd_1
Xwire76 wire76/A VGND VGND VDPWR VDPWR wire76/X sky130_fd_sc_hd__clkbuf_4
X_1278_ _2275_/Q _1393_/B _1277_/Y VGND VGND VDPWR VDPWR _1278_/Y sky130_fd_sc_hd__o21ai_1
XFILLER_19_217 VGND VGND VDPWR VDPWR sky130_fd_sc_hd__fill_1
XFILLER_19_228 VGND VGND VDPWR VDPWR sky130_fd_sc_hd__decap_3
XFILLER_42_253 VGND VGND VDPWR VDPWR sky130_fd_sc_hd__fill_1
XFILLER_42_264 VGND VGND VDPWR VDPWR sky130_fd_sc_hd__decap_3
XFILLER_42_297 VGND VGND VDPWR VDPWR sky130_fd_sc_hd__decap_3
XFILLER_63_64 VGND VGND VDPWR VDPWR sky130_fd_sc_hd__fill_1
XFILLER_10_194 VGND VGND VDPWR VDPWR sky130_fd_sc_hd__fill_2
XFILLER_69_106 VGND VGND VDPWR VDPWR sky130_fd_sc_hd__fill_1
X_2250_ _2258_/CLK hold60/X hold24/X VGND VGND VDPWR VDPWR hold64/A sky130_fd_sc_hd__dfrtp_1
X_1201_ _1201_/A _1201_/B _1201_/C VGND VGND VDPWR VDPWR _1202_/D sky130_fd_sc_hd__nand3_1
XFILLER_25_209 VGND VGND VDPWR VDPWR sky130_fd_sc_hd__fill_1
XPHY_EDGE_ROW_47_Right_66 VGND VDPWR sky130_fd_sc_hd__tapvpwrvgnd_1
X_1063_ _1063_/A _1294_/B _1401_/A _1367_/B VGND VGND VDPWR VDPWR _1158_/B sky130_fd_sc_hd__or4_1
X_2181_ clkload6/A _2181_/D VGND VGND VDPWR VDPWR _2181_/Q sky130_fd_sc_hd__dfxtp_1
X_1132_ _1643_/A _1643_/B VGND VGND VDPWR VDPWR _1162_/A sky130_fd_sc_hd__nor2_1
XFILLER_33_264 VGND VGND VDPWR VDPWR sky130_fd_sc_hd__fill_1
XPHY_EDGE_ROW_56_Right_75 VGND VDPWR sky130_fd_sc_hd__tapvpwrvgnd_1
XTAP_TAPCELL_ROW_50_207 VGND VDPWR sky130_fd_sc_hd__tapvpwrvgnd_1
Xu_sub.u_core.u_regfile.g_nibsel\[1\].g_nib\[3\].u_m2 u_sub.u_core.u_regfile.g_nibsel\[1\].g_nib\[3\].u_lo/X
+ u_sub.u_core.u_regfile.g_nibsel\[1\].g_nib\[3\].u_hi/X max_cap1/X VGND VGND VDPWR
+ VDPWR u_sub.u_core.u_regfile.g_port\[3\].u_b/A0 sky130_fd_sc_hd__mux2_1
X_1965_ _2112_/A _1965_/B _1965_/C VGND VGND VDPWR VDPWR _1965_/X sky130_fd_sc_hd__or3_1
Xu_sub.u_timer.u_cg_wd.u_icg delaybuf_5_clk/A _1500_/Y VGND VGND VDPWR VDPWR u_sub.u_timer.u_cg_wd.u_icg/GCLK
+ sky130_fd_sc_hd__dlclkp_1
X_1896_ _2315_/A _2116_/C _1895_/Y VGND VGND VDPWR VDPWR _1896_/Y sky130_fd_sc_hd__a21oi_1
XFILLER_68_161 VGND VGND VDPWR VDPWR sky130_fd_sc_hd__fill_1
XPHY_EDGE_ROW_65_Right_84 VGND VDPWR sky130_fd_sc_hd__tapvpwrvgnd_1
XPHY_EDGE_ROW_74_Right_93 VGND VDPWR sky130_fd_sc_hd__tapvpwrvgnd_1
XFILLER_58_86 VGND VGND VDPWR VDPWR sky130_fd_sc_hd__decap_3
XFILLER_59_183 VGND VGND VDPWR VDPWR sky130_fd_sc_hd__decap_3
XFILLER_59_194 VGND VGND VDPWR VDPWR sky130_fd_sc_hd__fill_2
XTAP_TAPCELL_ROW_72_321 VGND VDPWR sky130_fd_sc_hd__tapvpwrvgnd_1
XFILLER_15_231 VGND VGND VDPWR VDPWR sky130_fd_sc_hd__decap_3
XFILLER_30_212 VGND VGND VDPWR VDPWR sky130_fd_sc_hd__decap_3
X_1750_ _1750_/A _1750_/B _1750_/C VGND VGND VDPWR VDPWR _1762_/B sky130_fd_sc_hd__nand3_1
XPHY_EDGE_ROW_30_2_2_Right_49 VGND VDPWR sky130_fd_sc_hd__tapvpwrvgnd_1
Xmax_cap105 _1687_/B VGND VGND VDPWR VDPWR _1732_/D sky130_fd_sc_hd__clkbuf_4
Xmax_cap116 _1144_/B VGND VGND VDPWR VDPWR _1601_/A sky130_fd_sc_hd__buf_2
X_1681_ _1681_/A _1681_/B _1681_/C VGND VGND VDPWR VDPWR _1708_/A sky130_fd_sc_hd__and3_1
XFILLER_38_323 VGND VGND VDPWR VDPWR sky130_fd_sc_hd__fill_1
XFILLER_65_131 VGND VGND VDPWR VDPWR sky130_fd_sc_hd__decap_3
X_2302_ _2302_/D _2303_/GATE VGND VGND VDPWR VDPWR _2302_/Q sky130_fd_sc_hd__dlxtp_1
X_2233_ clkload7/A _2233_/D _2291_/D VGND VGND VDPWR VDPWR _2233_/Q sky130_fd_sc_hd__dfrtp_1
X_2164_ _2291_/CLK _2164_/D VGND VGND VDPWR VDPWR _2164_/Q sky130_fd_sc_hd__dfxtp_1
XFILLER_53_315 VGND VGND VDPWR VDPWR sky130_fd_sc_hd__fill_1
XFILLER_65_197 VGND VGND VDPWR VDPWR sky130_fd_sc_hd__fill_1
X_1046_ _1200_/A VGND VGND VDPWR VDPWR _1118_/A sky130_fd_sc_hd__inv_1
X_1115_ _1364_/A _1109_/Y _1114_/Y VGND VGND VDPWR VDPWR _1271_/A sky130_fd_sc_hd__o21ai_1
X_2095_ _2297_/Q _2064_/Y _2094_/Y VGND VGND VDPWR VDPWR _2095_/Y sky130_fd_sc_hd__a21oi_1
X_1948_ _1795_/B _1477_/B _2186_/Q VGND VGND VDPWR VDPWR _1948_/X sky130_fd_sc_hd__o21a_1
X_1879_ _1881_/C _1663_/B _1878_/Y _1904_/A VGND VGND VDPWR VDPWR _1879_/Y sky130_fd_sc_hd__a211oi_1
XFILLER_56_175 VGND VGND VDPWR VDPWR sky130_fd_sc_hd__decap_3
XFILLER_12_212 VGND VGND VDPWR VDPWR sky130_fd_sc_hd__decap_3
XFILLER_44_66 VGND VGND VDPWR VDPWR sky130_fd_sc_hd__fill_2
XFILLER_71_134 VGND VGND VDPWR VDPWR sky130_fd_sc_hd__fill_2
XFILLER_71_167 VGND VGND VDPWR VDPWR sky130_fd_sc_hd__decap_3
XFILLER_71_189 VGND VGND VDPWR VDPWR sky130_fd_sc_hd__decap_3
XFILLER_8_216 VGND VGND VDPWR VDPWR sky130_fd_sc_hd__fill_1
XFILLER_69_85 VGND VGND VDPWR VDPWR sky130_fd_sc_hd__fill_1
XFILLER_62_134 VGND VGND VDPWR VDPWR sky130_fd_sc_hd__fill_2
XFILLER_62_145 VGND VGND VDPWR VDPWR sky130_fd_sc_hd__decap_3
XFILLER_62_167 VGND VGND VDPWR VDPWR sky130_fd_sc_hd__decap_3
X_1802_ _2150_/Q _2149_/Q VGND VGND VDPWR VDPWR _1803_/B sky130_fd_sc_hd__xor2_1
X_1733_ _2148_/Q _1795_/B _1733_/C _1915_/B VGND VGND VDPWR VDPWR _1733_/Y sky130_fd_sc_hd__nor4_1
X_1664_ _1881_/C _1659_/Y _1663_/Y VGND VGND VDPWR VDPWR _1903_/B sky130_fd_sc_hd__a21oi_1
X_1595_ _1599_/B _1597_/B VGND VGND VDPWR VDPWR _1595_/X sky130_fd_sc_hd__and2_1
X_2216_ clkload8/A _2216_/D VGND VGND VDPWR VDPWR _2216_/Q sky130_fd_sc_hd__dfxtp_1
X_2147_ clkload3/A _2147_/D VGND VGND VDPWR VDPWR _2147_/Q sky130_fd_sc_hd__dfxtp_1
XFILLER_41_307 VGND VGND VDPWR VDPWR sky130_fd_sc_hd__decap_3
XFILLER_53_167 VGND VGND VDPWR VDPWR sky130_fd_sc_hd__decap_3
XFILLER_53_178 VGND VGND VDPWR VDPWR sky130_fd_sc_hd__fill_2
X_2078_ _2088_/A _2097_/B _2077_/Y VGND VGND VDPWR VDPWR _2212_/D sky130_fd_sc_hd__a21oi_1
Xdelaybuf_14_clk clkload1/A VGND VGND VDPWR VDPWR delaybuf_5_clk/A sky130_fd_sc_hd__clkbuf_2
XFILLER_29_197 VGND VGND VDPWR VDPWR sky130_fd_sc_hd__decap_3
XFILLER_71_31 VGND VGND VDPWR VDPWR sky130_fd_sc_hd__decap_3
XFILLER_71_53 VGND VGND VDPWR VDPWR sky130_fd_sc_hd__decap_3
X_1380_ _1638_/A _1368_/X _1370_/X _1379_/Y VGND VGND VDPWR VDPWR _1380_/Y sky130_fd_sc_hd__a31oi_1
XFILLER_35_112 VGND VGND VDPWR VDPWR sky130_fd_sc_hd__decap_3
X_2001_ _2001_/A _2018_/A VGND VGND VDPWR VDPWR _2004_/A sky130_fd_sc_hd__nand2_1
XFILLER_50_115 VGND VGND VDPWR VDPWR sky130_fd_sc_hd__decap_3
XTAP_TAPCELL_ROW_45_184 VGND VDPWR sky130_fd_sc_hd__tapvpwrvgnd_1
X_1716_ _2262_/Q _1716_/B VGND VGND VDPWR VDPWR _1716_/Y sky130_fd_sc_hd__nor2_1
X_1647_ _1152_/A _2167_/Q _1648_/S VGND VGND VDPWR VDPWR _1671_/A sky130_fd_sc_hd__mux2_1
X_1578_ _1578_/A wire85/X VGND VGND VDPWR VDPWR _1580_/C sky130_fd_sc_hd__xnor2_1
XTAP_TAPCELL_ROW_68_298 VGND VDPWR sky130_fd_sc_hd__tapvpwrvgnd_1
XFILLER_41_137 VGND VGND VDPWR VDPWR sky130_fd_sc_hd__fill_1
XFILLER_41_23 VGND VGND VDPWR VDPWR sky130_fd_sc_hd__fill_2
XFILLER_41_78 VGND VGND VDPWR VDPWR sky130_fd_sc_hd__decap_3
XFILLER_64_218 VGND VGND VDPWR VDPWR sky130_fd_sc_hd__fill_2
XFILLER_66_75 VGND VGND VDPWR VDPWR sky130_fd_sc_hd__decap_3
XTAP_TAPCELL_ROW_59_254 VGND VDPWR sky130_fd_sc_hd__tapvpwrvgnd_1
XFILLER_32_137 VGND VGND VDPWR VDPWR sky130_fd_sc_hd__decap_3
Xu_sub.u_timer.g_cmp\[0\].u_cg.u_icg delaybuf_5_clk/A _1611_/Y VGND VGND VDPWR VDPWR
+ clkbuf_0_u_sub.u_timer.g_cmp\[0\].g/A sky130_fd_sc_hd__dlclkp_1
XTAP_TAPCELL_ROW_42_165 VGND VDPWR sky130_fd_sc_hd__tapvpwrvgnd_1
X_1501_ _2234_/Q _2232_/Q _2236_/Q VGND VGND VDPWR VDPWR _1501_/Y sky130_fd_sc_hd__nor3_1
X_1432_ _2116_/A _1432_/B VGND VGND VDPWR VDPWR _1795_/B sky130_fd_sc_hd__nand2_1
X_1363_ _1856_/A1 _1635_/B _1099_/Y _1362_/Y VGND VGND VDPWR VDPWR _1364_/B sky130_fd_sc_hd__a22oi_1
XFILLER_63_273 VGND VGND VDPWR VDPWR sky130_fd_sc_hd__fill_2
X_1294_ _1914_/S _1294_/B _1367_/C VGND VGND VDPWR VDPWR _1294_/Y sky130_fd_sc_hd__nor3_1
XFILLER_54_273 VGND VGND VDPWR VDPWR sky130_fd_sc_hd__decap_3
XFILLER_52_66 VGND VGND VDPWR VDPWR sky130_fd_sc_hd__fill_2
XPHY_EDGE_ROW_24_2_2_Right_43 VGND VDPWR sky130_fd_sc_hd__tapvpwrvgnd_1
XFILLER_45_284 VGND VGND VDPWR VDPWR sky130_fd_sc_hd__fill_2
XFILLER_60_243 VGND VGND VDPWR VDPWR sky130_fd_sc_hd__decap_3
XFILLER_60_287 VGND VGND VDPWR VDPWR sky130_fd_sc_hd__fill_1
X_1981_ _1527_/A _1979_/Y _1980_/Y VGND VGND VDPWR VDPWR _2195_/D sky130_fd_sc_hd__a21oi_1
X_1415_ _2025_/B _1416_/B _1416_/C VGND VGND VDPWR VDPWR _1898_/B sky130_fd_sc_hd__and3_1
X_1346_ _1352_/A _1348_/B VGND VGND VDPWR VDPWR _1346_/Y sky130_fd_sc_hd__nand2_1
XFILLER_51_232 VGND VGND VDPWR VDPWR sky130_fd_sc_hd__fill_1
Xwire88 wire88/A VGND VGND VDPWR VDPWR wire88/X sky130_fd_sc_hd__buf_2
Xwire77 wire77/A VGND VGND VDPWR VDPWR wire77/X sky130_fd_sc_hd__buf_1
X_1277_ _1395_/B _1541_/C VGND VGND VDPWR VDPWR _1277_/Y sky130_fd_sc_hd__nand2_1
Xu_sub.u_core.u_regfile.g_nibsel\[2\].g_nib\[1\].u_m2 u_sub.u_core.u_regfile.g_nibsel\[2\].g_nib\[1\].u_lo/X
+ u_sub.u_core.u_regfile.g_nibsel\[2\].g_nib\[1\].u_hi/X max_cap75/X VGND VGND VDPWR
+ VDPWR u_sub.u_core.u_regfile.g_port\[1\].u_b/A1 sky130_fd_sc_hd__mux2_1
XFILLER_63_10 VGND VGND VDPWR VDPWR sky130_fd_sc_hd__decap_3
XFILLER_63_32 VGND VGND VDPWR VDPWR sky130_fd_sc_hd__fill_2
XFILLER_6_188 VGND VGND VDPWR VDPWR sky130_fd_sc_hd__fill_1
XFILLER_33_7 VGND VGND VDPWR VDPWR sky130_fd_sc_hd__decap_3
X_2180_ clkload4/A _2180_/D VGND VGND VDPWR VDPWR _2180_/Q sky130_fd_sc_hd__dfxtp_1
X_1200_ _1200_/A _1200_/B VGND VGND VDPWR VDPWR _1200_/Y sky130_fd_sc_hd__nor2_1
X_1062_ _1063_/A _1294_/B _1401_/A _1367_/B VGND VGND VDPWR VDPWR _1062_/Y sky130_fd_sc_hd__nor4_1
X_1131_ _1122_/C _1214_/A _1131_/C _1131_/D VGND VGND VDPWR VDPWR _1643_/B sky130_fd_sc_hd__nand4b_1
XTAP_TAPCELL_ROW_50_208 VGND VDPWR sky130_fd_sc_hd__tapvpwrvgnd_1
X_1964_ _2112_/A _1965_/B _1965_/C VGND VGND VDPWR VDPWR _1972_/B sky130_fd_sc_hd__nor3_1
X_1895_ _1499_/C _1915_/B _1893_/Y _1894_/Y _1965_/C VGND VGND VDPWR VDPWR _1895_/Y
+ sky130_fd_sc_hd__o32ai_1
X_1329_ _1836_/B _1329_/B VGND VGND VDPWR VDPWR _1329_/Y sky130_fd_sc_hd__nor2_1
XFILLER_33_13 VGND VGND VDPWR VDPWR sky130_fd_sc_hd__decap_3
XFILLER_33_35 VGND VGND VDPWR VDPWR sky130_fd_sc_hd__decap_3
X_2301_ _2301_/D _2301_/GATE VGND VGND VDPWR VDPWR _2301_/Q sky130_fd_sc_hd__dlxtp_1
Xmax_cap106 _1147_/D VGND VGND VDPWR VDPWR _1395_/B sky130_fd_sc_hd__clkbuf_2
Xmax_cap117 _1122_/D VGND VGND VDPWR VDPWR _1214_/A sky130_fd_sc_hd__clkbuf_4
X_1680_ _1680_/A _1680_/B VGND VGND VDPWR VDPWR _1681_/C sky130_fd_sc_hd__nand2_1
XFILLER_38_302 VGND VGND VDPWR VDPWR sky130_fd_sc_hd__decap_3
X_1114_ _1828_/A1 _1716_/B _1112_/Y _2243_/Q VGND VGND VDPWR VDPWR _1114_/Y sky130_fd_sc_hd__a22oi_1
Xclkbuf_leaf_2_clk clkbuf_leaf_4_clk/A VGND VGND VDPWR VDPWR clkbuf_leaf_2_clk/X sky130_fd_sc_hd__clkbuf_2
X_2232_ clkload7/A _2232_/D _2291_/D VGND VGND VDPWR VDPWR _2232_/Q sky130_fd_sc_hd__dfrtp_1
X_2163_ _2291_/CLK _2163_/D VGND VGND VDPWR VDPWR _2163_/Q sky130_fd_sc_hd__dfxtp_1
XFILLER_21_235 VGND VGND VDPWR VDPWR sky130_fd_sc_hd__fill_1
X_1045_ _2158_/Q VGND VGND VDPWR VDPWR _1811_/B sky130_fd_sc_hd__inv_1
X_2094_ _2208_/Q _2296_/Q VGND VGND VDPWR VDPWR _2094_/Y sky130_fd_sc_hd__xnor2_1
X_1947_ _2185_/Q wire2/X _1946_/Y _1803_/A VGND VGND VDPWR VDPWR _2185_/D sky130_fd_sc_hd__o211a_1
X_1878_ _1881_/C _1878_/B VGND VGND VDPWR VDPWR _1878_/Y sky130_fd_sc_hd__nor2_1
XFILLER_44_305 VGND VGND VDPWR VDPWR sky130_fd_sc_hd__fill_1
XFILLER_56_121 VGND VGND VDPWR VDPWR sky130_fd_sc_hd__decap_3
XFILLER_56_143 VGND VGND VDPWR VDPWR sky130_fd_sc_hd__decap_3
XFILLER_71_146 VGND VGND VDPWR VDPWR sky130_fd_sc_hd__decap_3
XFILLER_60_66 VGND VGND VDPWR VDPWR sky130_fd_sc_hd__fill_2
XFILLER_47_121 VGND VGND VDPWR VDPWR sky130_fd_sc_hd__decap_3
XFILLER_62_157 VGND VGND VDPWR VDPWR sky130_fd_sc_hd__decap_3
Xu_sub.u_core.u_regfile.g_word\[3\].g_byte\[3\].u_lat wire103/X wire101/X wire100/X
+ wire97/X wire95/X max_cap93/X max_cap91/X max_cap89/X u_sub.u_core.u_regfile.g_word\[3\].g_byte\[3\].u_lat/GATE
+ VGND VDPWR u_sub.u_core.u_regfile.g_word\[3\].g_byte\[3\].u_lat/Q0 u_sub.u_core.u_regfile.g_word\[3\].g_byte\[3\].u_lat/Q1
+ u_sub.u_core.u_regfile.g_word\[3\].g_byte\[3\].u_lat/Q2 u_sub.u_core.u_regfile.g_word\[3\].g_byte\[3\].u_lat/Q3
+ u_sub.u_core.u_regfile.g_word\[3\].g_byte\[3\].u_lat/Q4 u_sub.u_core.u_regfile.g_word\[3\].g_byte\[3\].u_lat/Q5
+ u_sub.u_core.u_regfile.g_word\[3\].g_byte\[3\].u_lat/Q6 u_sub.u_core.u_regfile.g_word\[3\].g_byte\[3\].u_lat/Q7
+ dlxtp8_x1
X_1801_ _2149_/Q _1801_/B VGND VGND VDPWR VDPWR _2149_/D sky130_fd_sc_hd__nor2_1
X_1732_ _2186_/Q _1795_/B _1733_/C _1732_/D VGND VGND VDPWR VDPWR wire2/A sky130_fd_sc_hd__nor4_1
X_1663_ _1881_/C _1663_/B VGND VGND VDPWR VDPWR _1663_/Y sky130_fd_sc_hd__nor2_1
Xu_adc_23 VGND VGND VDPWR VDPWR u_adc_23/HI u_adc_23/LO sky130_fd_sc_hd__conb_1
X_1594_ _1598_/B _1597_/B VGND VGND VDPWR VDPWR _1594_/X sky130_fd_sc_hd__and2_1
X_2215_ clkload8/A _2215_/D VGND VGND VDPWR VDPWR _2215_/Q sky130_fd_sc_hd__dfxtp_1
X_2146_ clkload6/A _2146_/D VGND VGND VDPWR VDPWR _2146_/Q sky130_fd_sc_hd__dfxtp_1
X_2077_ _2212_/Q _2088_/A _2123_/A VGND VGND VDPWR VDPWR _2077_/Y sky130_fd_sc_hd__o21ai_1
XPHY_EDGE_ROW_46_Left_105 VGND VDPWR sky130_fd_sc_hd__tapvpwrvgnd_1
XPHY_EDGE_ROW_55_Left_114 VGND VDPWR sky130_fd_sc_hd__tapvpwrvgnd_1
XFILLER_44_102 VGND VGND VDPWR VDPWR sky130_fd_sc_hd__fill_1
XFILLER_44_157 VGND VGND VDPWR VDPWR sky130_fd_sc_hd__decap_3
XFILLER_44_179 VGND VGND VDPWR VDPWR sky130_fd_sc_hd__fill_1
XFILLER_71_10 VGND VGND VDPWR VDPWR sky130_fd_sc_hd__decap_3
XPHY_EDGE_ROW_64_Left_123 VGND VDPWR sky130_fd_sc_hd__tapvpwrvgnd_1
XFILLER_52_190 VGND VGND VDPWR VDPWR sky130_fd_sc_hd__decap_3
Xdelaybuf_7_clk delaybuf_7_clk/A VGND VGND VDPWR VDPWR delaybuf_8_clk/A sky130_fd_sc_hd__clkbuf_2
XPHY_EDGE_ROW_73_Left_132 VGND VDPWR sky130_fd_sc_hd__tapvpwrvgnd_1
XFILLER_35_124 VGND VGND VDPWR VDPWR sky130_fd_sc_hd__fill_2
X_2000_ _2206_/Q _1999_/X _2015_/B VGND VGND VDPWR VDPWR _2018_/A sky130_fd_sc_hd__a21oi_1
XTAP_TAPCELL_ROW_45_185 VGND VDPWR sky130_fd_sc_hd__tapvpwrvgnd_1
X_1715_ _1716_/B _1902_/A _1714_/Y VGND VGND VDPWR VDPWR _2273_/D sky130_fd_sc_hd__a21oi_1
X_1646_ _1275_/Y _1902_/B _1645_/Y VGND VGND VDPWR VDPWR _1681_/B sky130_fd_sc_hd__o21a_1
XFILLER_58_205 VGND VGND VDPWR VDPWR sky130_fd_sc_hd__fill_1
XFILLER_58_238 VGND VGND VDPWR VDPWR sky130_fd_sc_hd__decap_3
XFILLER_58_249 VGND VGND VDPWR VDPWR sky130_fd_sc_hd__decap_3
X_1577_ _1590_/A _1581_/A VGND VGND VDPWR VDPWR _1610_/A sky130_fd_sc_hd__nand2b_1
XTAP_TAPCELL_ROW_68_299 VGND VDPWR sky130_fd_sc_hd__tapvpwrvgnd_1
X_2129_ clkload5/A hold45/X VGND VGND VDPWR VDPWR _2129_/Q sky130_fd_sc_hd__dfxtp_1
XPHY_EDGE_ROW_11_2_2_Left_0 VGND VDPWR sky130_fd_sc_hd__tapvpwrvgnd_1
XTAP_TAPCELL_ROW_59_255 VGND VDPWR sky130_fd_sc_hd__tapvpwrvgnd_1
Xclkbuf_1_0__f_u_sub.u_timer.u_cg_wd.gclk_o clkbuf_0_u_sub.u_timer.u_cg_wd.gclk_o/X
+ VGND VGND VDPWR VDPWR _2294_/CLK sky130_fd_sc_hd__clkbuf_2
XFILLER_32_149 VGND VGND VDPWR VDPWR sky130_fd_sc_hd__fill_2
XFILLER_40_160 VGND VGND VDPWR VDPWR sky130_fd_sc_hd__decap_3
XTAP_TAPCELL_ROW_42_166 VGND VDPWR sky130_fd_sc_hd__tapvpwrvgnd_1
XFILLER_63_7 VGND VGND VDPWR VDPWR sky130_fd_sc_hd__decap_3
Xu_sub.u_core.u_regfile.g_nibsel\[2\].g_nib\[3\].u_hi u_sub.u_core.u_regfile.g_word\[2\].g_byte\[2\].u_lat/Q3
+ u_sub.u_core.u_regfile.g_word\[2\].g_byte\[2\].u_lat/Q7 u_sub.u_core.u_regfile.g_word\[2\].g_byte\[3\].u_lat/Q3
+ u_sub.u_core.u_regfile.g_word\[2\].g_byte\[3\].u_lat/Q7 max_cap7/X _1632_/Y VGND
+ VGND VDPWR VDPWR u_sub.u_core.u_regfile.g_nibsel\[2\].g_nib\[3\].u_hi/X tg_mux4_x1
X_1500_ _1612_/B VGND VGND VDPWR VDPWR _1500_/Y sky130_fd_sc_hd__inv_1
X_1431_ _2116_/A _1432_/B VGND VGND VDPWR VDPWR _1862_/B sky130_fd_sc_hd__and2_1
X_1362_ _1362_/A _1362_/B VGND VGND VDPWR VDPWR _1362_/Y sky130_fd_sc_hd__nand2_1
X_1293_ _1848_/A _1152_/A _1208_/B VGND VGND VDPWR VDPWR _1293_/Y sky130_fd_sc_hd__o21ai_1
XFILLER_55_219 VGND VGND VDPWR VDPWR sky130_fd_sc_hd__decap_3
X_1629_ _1629_/A _1629_/B VGND VGND VDPWR VDPWR _1630_/B sky130_fd_sc_hd__xnor2_1
XFILLER_39_293 VGND VGND VDPWR VDPWR sky130_fd_sc_hd__decap_3
XTAP_TAPCELL_ROW_64_280 VGND VDPWR sky130_fd_sc_hd__tapvpwrvgnd_1
X_1980_ _2195_/Q _1527_/A _2123_/A VGND VGND VDPWR VDPWR _1980_/Y sky130_fd_sc_hd__o21ai_1
XFILLER_61_4 VGND VGND VDPWR VDPWR sky130_fd_sc_hd__decap_3
XTAP_TAPCELL_ROW_78_350 VGND VDPWR sky130_fd_sc_hd__tapvpwrvgnd_1
X_1414_ _2034_/S hold48/A hold46/A hold49/A VGND VGND VDPWR VDPWR _1416_/C sky130_fd_sc_hd__and4b_1
X_1345_ _1383_/A _1345_/B VGND VGND VDPWR VDPWR _1348_/B sky130_fd_sc_hd__xnor2_1
X_1276_ _1276_/A _1643_/C VGND VGND VDPWR VDPWR _1465_/C sky130_fd_sc_hd__nor2_1
XFILLER_51_211 VGND VGND VDPWR VDPWR sky130_fd_sc_hd__decap_3
Xwire67 wire67/A VGND VGND VDPWR VDPWR wire67/X sky130_fd_sc_hd__buf_6
Xwire12 wire13/X VGND VGND VDPWR VDPWR uio_out[7] sky130_fd_sc_hd__buf_4
XFILLER_47_89 VGND VGND VDPWR VDPWR sky130_fd_sc_hd__decap_3
X_1130_ _1137_/A _1182_/A _1200_/A VGND VGND VDPWR VDPWR _1643_/A sky130_fd_sc_hd__or3_1
XFILLER_33_211 VGND VGND VDPWR VDPWR sky130_fd_sc_hd__decap_3
XTAP_TAPCELL_ROW_50_209 VGND VDPWR sky130_fd_sc_hd__tapvpwrvgnd_1
X_1061_ _1914_/S _1495_/A VGND VGND VDPWR VDPWR _1691_/A sky130_fd_sc_hd__nand2_1
X_1963_ _1963_/A _1963_/B VGND VGND VDPWR VDPWR _2190_/D sky130_fd_sc_hd__nor2_1
X_1894_ _2192_/Q _1476_/B _1887_/B _1979_/B VGND VGND VDPWR VDPWR _1894_/Y sky130_fd_sc_hd__a22oi_1
XFILLER_24_200 VGND VGND VDPWR VDPWR sky130_fd_sc_hd__decap_3
X_1328_ _1328_/A1 _1552_/A _1887_/B _1141_/A VGND VGND VDPWR VDPWR _1329_/B sky130_fd_sc_hd__a22oi_1
X_1259_ _2157_/Q _1259_/B VGND VGND VDPWR VDPWR _1829_/B sky130_fd_sc_hd__nor2_1
XFILLER_33_69 VGND VGND VDPWR VDPWR sky130_fd_sc_hd__decap_3
XFILLER_58_66 VGND VGND VDPWR VDPWR sky130_fd_sc_hd__fill_2
XFILLER_15_200 VGND VGND VDPWR VDPWR sky130_fd_sc_hd__decap_3
Xmax_cap107 _1102_/Y VGND VGND VDPWR VDPWR _1826_/B sky130_fd_sc_hd__buf_2
X_2300_ _2300_/D _2301_/GATE VGND VGND VDPWR VDPWR _2300_/Q sky130_fd_sc_hd__dlxtp_1
X_2231_ clkload7/A _2231_/D _2291_/D VGND VGND VDPWR VDPWR _2231_/Q sky130_fd_sc_hd__dfstp_2
XFILLER_65_111 VGND VGND VDPWR VDPWR sky130_fd_sc_hd__fill_1
XFILLER_65_188 VGND VGND VDPWR VDPWR sky130_fd_sc_hd__decap_3
X_1044_ _1213_/B VGND VGND VDPWR VDPWR _1044_/Y sky130_fd_sc_hd__inv_1
X_1113_ _1836_/B _1466_/A VGND VGND VDPWR VDPWR _1113_/Y sky130_fd_sc_hd__nand2_1
X_2162_ _2291_/CLK _2162_/D VGND VGND VDPWR VDPWR _2162_/Q sky130_fd_sc_hd__dfxtp_1
X_2093_ _2298_/Q _2093_/B VGND VGND VDPWR VDPWR _2093_/X sky130_fd_sc_hd__xor2_1
X_1946_ wire2/X _1946_/B VGND VGND VDPWR VDPWR _1946_/Y sky130_fd_sc_hd__nand2_1
X_1877_ _1659_/Y _1675_/Y _1881_/C VGND VGND VDPWR VDPWR _1877_/X sky130_fd_sc_hd__mux2_1
XTAP_TAPCELL_ROW_41_1_1_156 VGND VDPWR sky130_fd_sc_hd__tapvpwrvgnd_1
XFILLER_56_133 VGND VGND VDPWR VDPWR sky130_fd_sc_hd__decap_3
XFILLER_56_155 VGND VGND VDPWR VDPWR sky130_fd_sc_hd__fill_1
XFILLER_71_125 VGND VGND VDPWR VDPWR sky130_fd_sc_hd__decap_3
XFILLER_71_158 VGND VGND VDPWR VDPWR sky130_fd_sc_hd__decap_3
XFILLER_8_207 VGND VGND VDPWR VDPWR sky130_fd_sc_hd__decap_3
XFILLER_69_10 VGND VGND VDPWR VDPWR sky130_fd_sc_hd__decap_3
XFILLER_47_166 VGND VGND VDPWR VDPWR sky130_fd_sc_hd__decap_3
XFILLER_47_177 VGND VGND VDPWR VDPWR sky130_fd_sc_hd__decap_3
Xclkbuf_1_0__f_u_sub.u_core.addr_gclk clkbuf_0_u_sub.u_core.addr_gclk/X VGND VGND
+ VDPWR VDPWR _2273_/CLK sky130_fd_sc_hd__clkbuf_2
X_1800_ _2150_/Q wire71/A _1803_/A VGND VGND VDPWR VDPWR _1801_/B sky130_fd_sc_hd__o21ai_1
X_1731_ _1795_/B _1732_/D VGND VGND VDPWR VDPWR _1861_/B sky130_fd_sc_hd__nor2_1
X_1662_ wire85/X _1882_/C _1661_/Y VGND VGND VDPWR VDPWR _1663_/B sky130_fd_sc_hd__a21oi_1
XFILLER_38_100 VGND VGND VDPWR VDPWR sky130_fd_sc_hd__decap_3
X_2214_ clkload8/A _2214_/D VGND VGND VDPWR VDPWR _2214_/Q sky130_fd_sc_hd__dfxtp_1
X_1593_ _1601_/A _1601_/C VGND VGND VDPWR VDPWR _1597_/B sky130_fd_sc_hd__nor2b_1
XFILLER_53_158 VGND VGND VDPWR VDPWR sky130_fd_sc_hd__decap_3
X_2145_ clkload8/A _2145_/D VGND VGND VDPWR VDPWR _2145_/Q sky130_fd_sc_hd__dfxtp_1
X_2076_ _2076_/A _2076_/B VGND VGND VDPWR VDPWR _2097_/B sky130_fd_sc_hd__xnor2_1
XFILLER_61_180 VGND VGND VDPWR VDPWR sky130_fd_sc_hd__decap_3
X_1929_ _1921_/A _1924_/Y _1928_/Y _1683_/A VGND VGND VDPWR VDPWR _1929_/Y sky130_fd_sc_hd__o22ai_1
XFILLER_29_188 VGND VGND VDPWR VDPWR sky130_fd_sc_hd__decap_3
XFILLER_39_35 VGND VGND VDPWR VDPWR sky130_fd_sc_hd__fill_2
XFILLER_44_125 VGND VGND VDPWR VDPWR sky130_fd_sc_hd__decap_3
XFILLER_71_22 VGND VGND VDPWR VDPWR sky130_fd_sc_hd__decap_3
XFILLER_71_44 VGND VGND VDPWR VDPWR sky130_fd_sc_hd__decap_3
XFILLER_67_239 VGND VGND VDPWR VDPWR sky130_fd_sc_hd__decap_3
XFILLER_35_169 VGND VGND VDPWR VDPWR sky130_fd_sc_hd__fill_1
XFILLER_43_191 VGND VGND VDPWR VDPWR sky130_fd_sc_hd__decap_3
XTAP_TAPCELL_ROW_45_186 VGND VDPWR sky130_fd_sc_hd__tapvpwrvgnd_1
X_1714_ _2261_/Q _1716_/B VGND VGND VDPWR VDPWR _1714_/Y sky130_fd_sc_hd__nor2_1
X_1645_ _2159_/Q _1887_/B _1887_/C VGND VGND VDPWR VDPWR _1645_/Y sky130_fd_sc_hd__nand3_1
X_1576_ _2229_/Q _2233_/Q _1590_/A VGND VGND VDPWR VDPWR _1609_/A sky130_fd_sc_hd__a21oi_1
XFILLER_58_228 VGND VGND VDPWR VDPWR sky130_fd_sc_hd__decap_3
Xu_sub.u_core.u_regfile.g_nibsel\[3\].g_nib\[1\].u_hi u_sub.u_core.u_regfile.g_word\[3\].g_byte\[2\].u_lat/Q1
+ u_sub.u_core.u_regfile.g_word\[3\].g_byte\[2\].u_lat/Q5 u_sub.u_core.u_regfile.g_word\[3\].g_byte\[3\].u_lat/Q1
+ u_sub.u_core.u_regfile.g_word\[3\].g_byte\[3\].u_lat/Q5 _1623_/Y max_cap4/X VGND
+ VGND VDPWR VDPWR u_sub.u_core.u_regfile.g_nibsel\[3\].g_nib\[1\].u_hi/X tg_mux4_x1
XFILLER_41_106 VGND VGND VDPWR VDPWR sky130_fd_sc_hd__decap_3
X_2128_ clkload5/A _2128_/D VGND VGND VDPWR VDPWR hold47/A sky130_fd_sc_hd__dfxtp_1
X_2059_ _2220_/Q _2221_/Q _2106_/A _2222_/Q VGND VGND VDPWR VDPWR _2112_/B sky130_fd_sc_hd__a31oi_1
Xu_sub.u_core.u_regfile.g_ir\[3\].u_lat wire103/X wire101/X wire100/X wire97/X wire95/X
+ max_cap93/X max_cap91/X max_cap89/X u_sub.u_core.u_regfile.g_ir\[3\].u_lat/GATE
+ VGND VDPWR _1213_/B _1298_/B _1339_/B _1376_/A _1175_/A _1195_/A _1156_/B _1209_/A
+ dlxtp8_x1
XFILLER_66_66 VGND VGND VDPWR VDPWR sky130_fd_sc_hd__fill_2
XTAP_TAPCELL_ROW_59_256 VGND VDPWR sky130_fd_sc_hd__tapvpwrvgnd_1
XFILLER_25_191 VGND VGND VDPWR VDPWR sky130_fd_sc_hd__decap_3
XFILLER_32_117 VGND VGND VDPWR VDPWR sky130_fd_sc_hd__fill_1
XTAP_TAPCELL_ROW_42_167 VGND VDPWR sky130_fd_sc_hd__tapvpwrvgnd_1
X_1430_ _1477_/A _1430_/B VGND VGND VDPWR VDPWR _1430_/Y sky130_fd_sc_hd__nor2_1
X_1361_ hold59/A _1826_/B _1322_/B _2246_/Q hold64/A _1376_/B VGND VGND VDPWR VDPWR
+ _1362_/B sky130_fd_sc_hd__a222oi_1
X_1292_ _1298_/B _1376_/B _1360_/B _1195_/A VGND VGND VDPWR VDPWR _1292_/Y sky130_fd_sc_hd__a22oi_1
XFILLER_63_242 VGND VGND VDPWR VDPWR sky130_fd_sc_hd__decap_3
XFILLER_63_264 VGND VGND VDPWR VDPWR sky130_fd_sc_hd__fill_2
Xu_sub.u_core.u_regfile.g_ir\[1\].u_cg.u_icg clkbuf_leaf_4_clk/X _1608_/Y VGND VGND
+ VDPWR VDPWR u_sub.u_core.u_regfile.g_ir\[1\].u_lat/GATE sky130_fd_sc_hd__dlclkp_1
X_1628_ _1626_/Y _1628_/B VGND VGND VDPWR VDPWR _1629_/B sky130_fd_sc_hd__nand2b_1
X_1559_ _1539_/A _1200_/Y _1541_/C VGND VGND VDPWR VDPWR _1564_/D sky130_fd_sc_hd__o21ai_1
XTAP_TAPCELL_ROW_56_237 VGND VDPWR sky130_fd_sc_hd__tapvpwrvgnd_1
XTAP_TAPCELL_ROW_64_281 VGND VDPWR sky130_fd_sc_hd__tapvpwrvgnd_1
XFILLER_60_256 VGND VGND VDPWR VDPWR sky130_fd_sc_hd__decap_3
X_1413_ hold48/A hold60/A _2034_/S VGND VGND VDPWR VDPWR _1413_/X sky130_fd_sc_hd__mux2_1
XTAP_TAPCELL_ROW_78_351 VGND VDPWR sky130_fd_sc_hd__tapvpwrvgnd_1
Xwire13 wire13/A VGND VGND VDPWR VDPWR wire13/X sky130_fd_sc_hd__buf_2
X_1344_ _1716_/B _1330_/Y _1343_/Y VGND VGND VDPWR VDPWR _1345_/B sky130_fd_sc_hd__o21a_1
X_1275_ _1275_/A _1275_/B VGND VGND VDPWR VDPWR _1275_/Y sky130_fd_sc_hd__nand2_1
XFILLER_36_264 VGND VGND VDPWR VDPWR sky130_fd_sc_hd__decap_3
XTAP_TAPCELL_ROW_61_262 VGND VDPWR sky130_fd_sc_hd__tapvpwrvgnd_1
XFILLER_27_220 VGND VGND VDPWR VDPWR sky130_fd_sc_hd__fill_1
XTAP_TAPCELL_ROW_75_332 VGND VDPWR sky130_fd_sc_hd__tapvpwrvgnd_1
X_1060_ _1614_/A _1257_/B VGND VGND VDPWR VDPWR _1476_/B sky130_fd_sc_hd__nor2_1
XFILLER_33_289 VGND VGND VDPWR VDPWR sky130_fd_sc_hd__fill_1
X_1962_ wire67/X _1951_/Y _1803_/A VGND VGND VDPWR VDPWR _1963_/B sky130_fd_sc_hd__o21ai_1
X_1893_ _2209_/Q _1914_/S _1892_/Y VGND VGND VDPWR VDPWR _1893_/Y sky130_fd_sc_hd__a21oi_1
XFILLER_24_212 VGND VGND VDPWR VDPWR sky130_fd_sc_hd__decap_3
XFILLER_71_307 VGND VGND VDPWR VDPWR sky130_fd_sc_hd__fill_1
X_1327_ _1327_/A _1327_/B VGND VGND VDPWR VDPWR _1352_/A sky130_fd_sc_hd__nor2_1
X_1258_ _1614_/A _1495_/A VGND VGND VDPWR VDPWR _1259_/B sky130_fd_sc_hd__nand2_1
X_1189_ _1189_/A _1189_/B _1189_/C VGND VGND VDPWR VDPWR _1199_/C sky130_fd_sc_hd__nor3_1
XPHY_EDGE_ROW_43_Right_62 VGND VDPWR sky130_fd_sc_hd__tapvpwrvgnd_1
XFILLER_58_89 VGND VGND VDPWR VDPWR sky130_fd_sc_hd__decap_3
XFILLER_59_186 VGND VGND VDPWR VDPWR sky130_fd_sc_hd__fill_2
XPHY_EDGE_ROW_52_Right_71 VGND VDPWR sky130_fd_sc_hd__tapvpwrvgnd_1
XFILLER_15_234 VGND VGND VDPWR VDPWR sky130_fd_sc_hd__fill_2
XFILLER_30_215 VGND VGND VDPWR VDPWR sky130_fd_sc_hd__decap_3
XPHY_EDGE_ROW_36_2_2_Right_55 VGND VDPWR sky130_fd_sc_hd__tapvpwrvgnd_1
XPHY_EDGE_ROW_61_Right_80 VGND VDPWR sky130_fd_sc_hd__tapvpwrvgnd_1
Xmax_cap119 _2002_/A VGND VGND VDPWR VDPWR _2117_/A sky130_fd_sc_hd__buf_4
Xu_sub.u_core.u_regfile.g_word\[1\].g_byte\[1\].u_cg.u_icg clkbuf_leaf_3_clk/X _1587_/Y
+ VGND VGND VDPWR VDPWR u_sub.u_core.u_regfile.g_word\[1\].g_byte\[1\].u_lat/GATE
+ sky130_fd_sc_hd__dlclkp_1
X_2230_ clkload7/A _2230_/D _2291_/D VGND VGND VDPWR VDPWR _2230_/Q sky130_fd_sc_hd__dfrtp_1
XFILLER_65_134 VGND VGND VDPWR VDPWR sky130_fd_sc_hd__decap_3
X_1043_ _1914_/S VGND VGND VDPWR VDPWR _1614_/A sky130_fd_sc_hd__inv_1
X_1112_ _1829_/A _1716_/B VGND VGND VDPWR VDPWR _1112_/Y sky130_fd_sc_hd__nor2_1
X_2161_ _2291_/CLK _2161_/D VGND VGND VDPWR VDPWR _2161_/Q sky130_fd_sc_hd__dfxtp_1
X_2092_ _2299_/Q _2092_/B VGND VGND VDPWR VDPWR _2092_/X sky130_fd_sc_hd__xor2_1
XFILLER_21_204 VGND VGND VDPWR VDPWR sky130_fd_sc_hd__fill_2
X_1945_ _2190_/Q _1951_/B VGND VGND VDPWR VDPWR _1946_/B sky130_fd_sc_hd__nand2_1
X_1876_ _1876_/A _1902_/B VGND VGND VDPWR VDPWR _1876_/Y sky130_fd_sc_hd__nor2_1
XTAP_TAPCELL_ROW_22_2_2_146 VGND VDPWR sky130_fd_sc_hd__tapvpwrvgnd_1
XTAP_TAPCELL_ROW_41_1_1_157 VGND VDPWR sky130_fd_sc_hd__tapvpwrvgnd_1
XFILLER_56_178 VGND VGND VDPWR VDPWR sky130_fd_sc_hd__decap_3
XFILLER_71_137 VGND VGND VDPWR VDPWR sky130_fd_sc_hd__decap_3
Xdelaybuf_17_clk delaybuf_17_clk/A VGND VGND VDPWR VDPWR delaybuf_18_clk/A sky130_fd_sc_hd__clkbuf_2
XFILLER_35_318 VGND VGND VDPWR VDPWR sky130_fd_sc_hd__fill_1
XFILLER_47_101 VGND VGND VDPWR VDPWR sky130_fd_sc_hd__fill_1
XFILLER_62_137 VGND VGND VDPWR VDPWR sky130_fd_sc_hd__decap_3
XFILLER_62_148 VGND VGND VDPWR VDPWR sky130_fd_sc_hd__decap_3
XFILLER_7_230 VGND VGND VDPWR VDPWR sky130_fd_sc_hd__decap_3
X_1730_ _1803_/A _2116_/A _1730_/C VGND VGND VDPWR VDPWR _1730_/X sky130_fd_sc_hd__and3_1
X_1661_ _2163_/Q wire85/X VGND VGND VDPWR VDPWR _1661_/Y sky130_fd_sc_hd__nor2_1
X_1592_ _1592_/A _1592_/B VGND VGND VDPWR VDPWR _1601_/C sky130_fd_sc_hd__and2_1
XFILLER_38_134 VGND VGND VDPWR VDPWR sky130_fd_sc_hd__fill_2
X_2213_ clkload8/A _2213_/D VGND VGND VDPWR VDPWR _2213_/Q sky130_fd_sc_hd__dfxtp_1
X_2144_ clkload8/A _2144_/D VGND VGND VDPWR VDPWR _2144_/Q sky130_fd_sc_hd__dfxtp_1
X_2075_ _2076_/A _2076_/B VGND VGND VDPWR VDPWR _2082_/C sky130_fd_sc_hd__nor2_1
XFILLER_61_192 VGND VGND VDPWR VDPWR sky130_fd_sc_hd__fill_2
X_1928_ _1392_/Y _1902_/B _1926_/Y _1927_/Y VGND VGND VDPWR VDPWR _1928_/Y sky130_fd_sc_hd__o22ai_1
X_1859_ _1499_/C _1858_/Y _1898_/B VGND VGND VDPWR VDPWR _1859_/Y sky130_fd_sc_hd__o21ai_1
XFILLER_55_35 VGND VGND VDPWR VDPWR sky130_fd_sc_hd__fill_2
XFILLER_71_56 VGND VGND VDPWR VDPWR sky130_fd_sc_hd__decap_3
XFILLER_4_233 VGND VGND VDPWR VDPWR sky130_fd_sc_hd__decap_3
XFILLER_35_115 VGND VGND VDPWR VDPWR sky130_fd_sc_hd__decap_3
XFILLER_50_118 VGND VGND VDPWR VDPWR sky130_fd_sc_hd__fill_2
X_1713_ _1716_/B _1876_/A _1712_/Y VGND VGND VDPWR VDPWR _2272_/D sky130_fd_sc_hd__a21oi_1
X_1644_ _1680_/A _1644_/B _1887_/C VGND VGND VDPWR VDPWR _1902_/B sky130_fd_sc_hd__or3_1
X_1575_ _2155_/Q _1580_/B _1574_/Y VGND VGND VDPWR VDPWR _1590_/A sky130_fd_sc_hd__o21ai_1
XFILLER_58_218 VGND VGND VDPWR VDPWR sky130_fd_sc_hd__decap_3
X_2127_ clkload5/A _2127_/D VGND VGND VDPWR VDPWR hold45/A sky130_fd_sc_hd__dfxtp_1
X_2058_ _2220_/Q _2221_/Q _2106_/A VGND VGND VDPWR VDPWR _2110_/B sky130_fd_sc_hd__nand3_1
XFILLER_66_78 VGND VGND VDPWR VDPWR sky130_fd_sc_hd__decap_3
XFILLER_40_195 VGND VGND VDPWR VDPWR sky130_fd_sc_hd__decap_3
XTAP_TAPCELL_ROW_42_168 VGND VDPWR sky130_fd_sc_hd__tapvpwrvgnd_1
Xu_sub.u_core.u_regfile.g_nibsel\[2\].g_nib\[3\].u_lo u_sub.u_core.u_regfile.g_word\[2\].g_byte\[0\].u_lat/Q3
+ u_sub.u_core.u_regfile.g_word\[2\].g_byte\[0\].u_lat/Q7 u_sub.u_core.u_regfile.g_word\[2\].g_byte\[1\].u_lat/Q3
+ u_sub.u_core.u_regfile.g_word\[2\].g_byte\[1\].u_lat/Q7 max_cap7/X max_cap4/X VGND
+ VGND VDPWR VDPWR u_sub.u_core.u_regfile.g_nibsel\[2\].g_nib\[3\].u_lo/X tg_mux4_x1
X_1360_ hold60/A _1360_/B VGND VGND VDPWR VDPWR _1362_/A sky130_fd_sc_hd__nand2_1
XFILLER_63_210 VGND VGND VDPWR VDPWR sky130_fd_sc_hd__decap_3
X_1291_ _1248_/B _1221_/B _1377_/B1 VGND VGND VDPWR VDPWR _1291_/Y sky130_fd_sc_hd__a21oi_1
XPHY_EDGE_ROW_40_2_2_Left_29 VGND VDPWR sky130_fd_sc_hd__tapvpwrvgnd_1
X_1627_ _1627_/A _1627_/B _1627_/C VGND VGND VDPWR VDPWR _1628_/B sky130_fd_sc_hd__nand3_1
X_1558_ _1848_/B _1558_/B _1558_/C VGND VGND VDPWR VDPWR _1561_/B sky130_fd_sc_hd__nand3_1
X_1489_ _2291_/D _2015_/B hold132/X VGND VGND VDPWR VDPWR _2041_/A sky130_fd_sc_hd__a21oi_1
XFILLER_39_251 VGND VGND VDPWR VDPWR sky130_fd_sc_hd__fill_1
XTAP_TAPCELL_ROW_56_238 VGND VDPWR sky130_fd_sc_hd__tapvpwrvgnd_1
XFILLER_60_246 VGND VGND VDPWR VDPWR sky130_fd_sc_hd__decap_3
XFILLER_9_188 VGND VGND VDPWR VDPWR sky130_fd_sc_hd__decap_3
XFILLER_9_199 VGND VGND VDPWR VDPWR sky130_fd_sc_hd__fill_2
X_1412_ hold39/A hold62/A _2034_/S VGND VGND VDPWR VDPWR _1416_/B sky130_fd_sc_hd__mux2_1
X_1343_ _1638_/A _1335_/Y _1338_/Y _1342_/Y _1206_/Y VGND VGND VDPWR VDPWR _1343_/Y
+ sky130_fd_sc_hd__o221ai_1
Xwire69 wire69/A VGND VGND VDPWR VDPWR wire69/X sky130_fd_sc_hd__buf_6
Xwire14 wire15/X VGND VGND VDPWR VDPWR uio_out[6] sky130_fd_sc_hd__buf_4
X_1274_ _1268_/Y _1272_/Y _1389_/A _1271_/Y _1266_/X VGND VGND VDPWR VDPWR _1275_/B
+ sky130_fd_sc_hd__o221ai_1
XTAP_TAPCELL_ROW_61_263 VGND VDPWR sky130_fd_sc_hd__tapvpwrvgnd_1
XTAP_TAPCELL_ROW_30_2_2_150 VGND VDPWR sky130_fd_sc_hd__tapvpwrvgnd_1
XFILLER_63_13 VGND VGND VDPWR VDPWR sky130_fd_sc_hd__fill_1
XFILLER_63_35 VGND VGND VDPWR VDPWR sky130_fd_sc_hd__decap_3
XFILLER_63_79 VGND VGND VDPWR VDPWR sky130_fd_sc_hd__fill_2
XFILLER_18_221 VGND VGND VDPWR VDPWR sky130_fd_sc_hd__fill_1
XFILLER_33_202 VGND VGND VDPWR VDPWR sky130_fd_sc_hd__fill_2
XTAP_TAPCELL_ROW_75_333 VGND VDPWR sky130_fd_sc_hd__tapvpwrvgnd_1
XFILLER_53_90 VGND VGND VDPWR VDPWR sky130_fd_sc_hd__decap_3
X_1961_ _2190_/Q _1961_/B VGND VGND VDPWR VDPWR _1963_/A sky130_fd_sc_hd__nor2_1
X_1892_ _1914_/S _2213_/Q VGND VGND VDPWR VDPWR _1892_/Y sky130_fd_sc_hd__nor2b_1
XFILLER_56_338 VGND VGND VDPWR VDPWR sky130_fd_sc_hd__fill_2
XFILLER_68_176 VGND VGND VDPWR VDPWR sky130_fd_sc_hd__fill_1
Xclkbuf_leaf_5_clk delaybuf_15_clk/X VGND VGND VDPWR VDPWR clkload1/A sky130_fd_sc_hd__clkbuf_2
X_1326_ _1660_/A1 _1466_/A _1113_/Y _2245_/Q VGND VGND VDPWR VDPWR _1327_/B sky130_fd_sc_hd__o22ai_1
XFILLER_33_16 VGND VGND VDPWR VDPWR sky130_fd_sc_hd__decap_3
XPHY_EDGE_ROW_17_2_2_Right_36 VGND VDPWR sky130_fd_sc_hd__tapvpwrvgnd_1
X_1257_ _2154_/Q _1257_/B VGND VGND VDPWR VDPWR _1887_/B sky130_fd_sc_hd__nor2_1
X_1188_ _1478_/A _1188_/B VGND VGND VDPWR VDPWR _1189_/C sky130_fd_sc_hd__nand2_1
Xu_sub.u_core.u_regfile.g_word\[2\].g_byte\[2\].u_lat wire103/X wire101/X max_cap99/X
+ wire97/X wire95/X max_cap93/X wire92/X max_cap89/X u_sub.u_core.u_regfile.g_word\[2\].g_byte\[2\].u_lat/GATE
+ VGND VDPWR u_sub.u_core.u_regfile.g_word\[2\].g_byte\[2\].u_lat/Q0 u_sub.u_core.u_regfile.g_word\[2\].g_byte\[2\].u_lat/Q1
+ u_sub.u_core.u_regfile.g_word\[2\].g_byte\[2\].u_lat/Q2 u_sub.u_core.u_regfile.g_word\[2\].g_byte\[2\].u_lat/Q3
+ u_sub.u_core.u_regfile.g_word\[2\].g_byte\[2\].u_lat/Q4 u_sub.u_core.u_regfile.g_word\[2\].g_byte\[2\].u_lat/Q5
+ u_sub.u_core.u_regfile.g_word\[2\].g_byte\[2\].u_lat/Q6 u_sub.u_core.u_regfile.g_word\[2\].g_byte\[2\].u_lat/Q7
+ dlxtp8_x1
XFILLER_38_305 VGND VGND VDPWR VDPWR sky130_fd_sc_hd__fill_2
X_2160_ clkload4/A _2160_/D VGND VGND VDPWR VDPWR _2160_/Q sky130_fd_sc_hd__dfxtp_1
XFILLER_38_338 VGND VGND VDPWR VDPWR sky130_fd_sc_hd__fill_2
X_1042_ _2155_/Q VGND VGND VDPWR VDPWR _1627_/A sky130_fd_sc_hd__inv_1
X_1111_ _1848_/B _2232_/Q VGND VGND VDPWR VDPWR _1466_/A sky130_fd_sc_hd__nand2_1
Xmax_cap1 wire76/X VGND VGND VDPWR VDPWR max_cap1/X sky130_fd_sc_hd__buf_6
X_2091_ _2301_/Q _2091_/B VGND VGND VDPWR VDPWR _2099_/A sky130_fd_sc_hd__xnor2_1
X_1944_ _2184_/Q wire2/X _1943_/Y _1803_/A VGND VGND VDPWR VDPWR _2184_/D sky130_fd_sc_hd__o211a_1
X_1875_ _1873_/Y _1874_/X _1868_/Y VGND VGND VDPWR VDPWR _2171_/D sky130_fd_sc_hd__a21oi_1
XTAP_TAPCELL_ROW_41_1_1_158 VGND VDPWR sky130_fd_sc_hd__tapvpwrvgnd_1
XFILLER_44_319 VGND VGND VDPWR VDPWR sky130_fd_sc_hd__fill_1
XFILLER_56_124 VGND VGND VDPWR VDPWR sky130_fd_sc_hd__decap_3
XFILLER_56_146 VGND VGND VDPWR VDPWR sky130_fd_sc_hd__decap_3
X_2289_ _2289_/CLK _2289_/D VGND VGND VDPWR VDPWR hold29/A sky130_fd_sc_hd__dfxtp_1
X_1309_ _1313_/A _1309_/B VGND VGND VDPWR VDPWR _1310_/B sky130_fd_sc_hd__or2_1
XFILLER_71_149 VGND VGND VDPWR VDPWR sky130_fd_sc_hd__decap_3
XFILLER_47_124 VGND VGND VDPWR VDPWR sky130_fd_sc_hd__fill_2
XFILLER_47_135 VGND VGND VDPWR VDPWR sky130_fd_sc_hd__decap_3
XFILLER_47_146 VGND VGND VDPWR VDPWR sky130_fd_sc_hd__decap_3
XFILLER_47_157 VGND VGND VDPWR VDPWR sky130_fd_sc_hd__decap_3
X_1660_ _1660_/A1 _1654_/Y _1655_/X VGND VGND VDPWR VDPWR _1882_/C sky130_fd_sc_hd__a21oi_1
X_1591_ _1591_/A _1605_/B _1610_/A _1610_/B VGND VGND VDPWR VDPWR _1591_/Y sky130_fd_sc_hd__nor4_1
XFILLER_38_124 VGND VGND VDPWR VDPWR sky130_fd_sc_hd__fill_2
XFILLER_38_146 VGND VGND VDPWR VDPWR sky130_fd_sc_hd__decap_3
XFILLER_38_157 VGND VGND VDPWR VDPWR sky130_fd_sc_hd__decap_3
X_2212_ clkload8/A _2212_/D VGND VGND VDPWR VDPWR _2212_/Q sky130_fd_sc_hd__dfxtp_1
X_2143_ clkload8/A _2143_/D VGND VGND VDPWR VDPWR _2143_/Q sky130_fd_sc_hd__dfxtp_1
XFILLER_34_341 VGND VGND VDPWR VDPWR sky130_fd_sc_hd__decap_3
XFILLER_53_138 VGND VGND VDPWR VDPWR sky130_fd_sc_hd__fill_2
XFILLER_61_171 VGND VGND VDPWR VDPWR sky130_fd_sc_hd__decap_3
XTAP_TAPCELL_ROW_26_2_2_148 VGND VDPWR sky130_fd_sc_hd__tapvpwrvgnd_1
X_2074_ _2088_/A _2092_/B _2073_/Y VGND VGND VDPWR VDPWR _2211_/D sky130_fd_sc_hd__a21oi_1
X_1927_ _2164_/Q _1885_/A _1680_/A VGND VGND VDPWR VDPWR _1927_/Y sky130_fd_sc_hd__o21ai_1
X_1858_ _2215_/Q _1914_/S _2116_/B _1687_/B _1857_/Y VGND VGND VDPWR VDPWR _1858_/Y
+ sky130_fd_sc_hd__o2111ai_1
XPHY_EDGE_ROW_80_Right_99 VGND VDPWR sky130_fd_sc_hd__tapvpwrvgnd_1
X_1789_ _2145_/Q _1789_/B _1789_/C VGND VGND VDPWR VDPWR _1789_/Y sky130_fd_sc_hd__nand3_1
XFILLER_40_322 VGND VGND VDPWR VDPWR sky130_fd_sc_hd__fill_2
XFILLER_52_160 VGND VGND VDPWR VDPWR sky130_fd_sc_hd__decap_3
XFILLER_52_182 VGND VGND VDPWR VDPWR sky130_fd_sc_hd__decap_3
XFILLER_52_193 VGND VGND VDPWR VDPWR sky130_fd_sc_hd__decap_3
XFILLER_71_13 VGND VGND VDPWR VDPWR sky130_fd_sc_hd__decap_3
XFILLER_71_35 VGND VGND VDPWR VDPWR sky130_fd_sc_hd__decap_3
XPHY_EDGE_ROW_42_Left_101 VGND VDPWR sky130_fd_sc_hd__tapvpwrvgnd_1
XFILLER_43_171 VGND VGND VDPWR VDPWR sky130_fd_sc_hd__decap_3
XPHY_EDGE_ROW_51_Left_110 VGND VDPWR sky130_fd_sc_hd__tapvpwrvgnd_1
XANTENNA_1 ui_in[1] VGND VGND VDPWR VDPWR sky130_fd_sc_hd__diode_2
X_1712_ _2260_/Q _1716_/B VGND VGND VDPWR VDPWR _1712_/Y sky130_fd_sc_hd__nor2_1
X_1643_ _1643_/A _1643_/B _1643_/C VGND VGND VDPWR VDPWR _1887_/C sky130_fd_sc_hd__nor3_1
X_1574_ _1580_/B _1574_/B VGND VGND VDPWR VDPWR _1574_/Y sky130_fd_sc_hd__nand2_1
XFILLER_66_285 VGND VGND VDPWR VDPWR sky130_fd_sc_hd__fill_1
Xu_sub.u_core.u_regfile.g_nibsel\[3\].g_nib\[1\].u_lo u_sub.u_core.u_regfile.g_word\[3\].g_byte\[0\].u_lat/Q1
+ u_sub.u_core.u_regfile.g_word\[3\].g_byte\[0\].u_lat/Q5 u_sub.u_core.u_regfile.g_word\[3\].g_byte\[1\].u_lat/Q1
+ u_sub.u_core.u_regfile.g_word\[3\].g_byte\[1\].u_lat/Q5 max_cap80/X max_cap4/X VGND
+ VGND VDPWR VDPWR u_sub.u_core.u_regfile.g_nibsel\[3\].g_nib\[1\].u_lo/X tg_mux4_x1
X_2126_ _1923_/Y _1929_/Y _1581_/A VGND VGND VDPWR VDPWR _2179_/D sky130_fd_sc_hd__a21boi_1
X_2057_ _2217_/Q _2218_/Q _2219_/Q VGND VGND VDPWR VDPWR _2106_/A sky130_fd_sc_hd__and3_1
XFILLER_41_119 VGND VGND VDPWR VDPWR sky130_fd_sc_hd__decap_3
Xclkbuf_1_1__f_u_sub.u_timer.g_cmp\[0\].g clkbuf_0_u_sub.u_timer.g_cmp\[0\].g/X VGND
+ VGND VDPWR VDPWR _2299_/GATE sky130_fd_sc_hd__clkbuf_2
XFILLER_49_208 VGND VGND VDPWR VDPWR sky130_fd_sc_hd__fill_1
XFILLER_32_108 VGND VGND VDPWR VDPWR sky130_fd_sc_hd__decap_3
XFILLER_40_185 VGND VGND VDPWR VDPWR sky130_fd_sc_hd__decap_3
XTAP_TAPCELL_ROW_42_169 VGND VDPWR sky130_fd_sc_hd__tapvpwrvgnd_1
Xu_sub.u_core.u_regfile.g_nibsel\[1\].g_nib\[0\].u_hi u_sub.u_core.u_regfile.g_word\[1\].g_byte\[2\].u_lat/Q0
+ u_sub.u_core.u_regfile.g_word\[1\].g_byte\[2\].u_lat/Q4 u_sub.u_core.u_regfile.g_word\[1\].g_byte\[3\].u_lat/Q0
+ u_sub.u_core.u_regfile.g_word\[1\].g_byte\[3\].u_lat/Q4 max_cap6/X max_cap3/X VGND
+ VGND VDPWR VDPWR u_sub.u_core.u_regfile.g_nibsel\[1\].g_nib\[0\].u_hi/X tg_mux4_x1
XFILLER_63_200 VGND VGND VDPWR VDPWR sky130_fd_sc_hd__decap_3
XFILLER_63_255 VGND VGND VDPWR VDPWR sky130_fd_sc_hd__fill_2
X_1290_ _1144_/A _1221_/A _1222_/Y _1152_/A VGND VGND VDPWR VDPWR _1290_/Y sky130_fd_sc_hd__a22oi_1
X_1626_ _1627_/B _1627_/C _1627_/A VGND VGND VDPWR VDPWR _1626_/Y sky130_fd_sc_hd__a21oi_1
X_1557_ _2232_/Q _1539_/A _1541_/C _2235_/Q VGND VGND VDPWR VDPWR _1558_/C sky130_fd_sc_hd__a31o_1
X_1488_ _2313_/A _1488_/B _1488_/C VGND VGND VDPWR VDPWR _1989_/B sky130_fd_sc_hd__nand3_1
XFILLER_39_296 VGND VGND VDPWR VDPWR sky130_fd_sc_hd__fill_2
XFILLER_54_200 VGND VGND VDPWR VDPWR sky130_fd_sc_hd__fill_1
XTAP_TAPCELL_ROW_56_239 VGND VDPWR sky130_fd_sc_hd__tapvpwrvgnd_1
X_2109_ _2220_/Q _2106_/A _2221_/Q VGND VGND VDPWR VDPWR _2111_/A sky130_fd_sc_hd__a21oi_1
XFILLER_61_7 VGND VGND VDPWR VDPWR sky130_fd_sc_hd__decap_3
X_1411_ hold42/A hold54/A _2034_/S VGND VGND VDPWR VDPWR _2025_/B sky130_fd_sc_hd__mux2_1
X_1342_ _1297_/Y _1341_/Y _1638_/A VGND VGND VDPWR VDPWR _1342_/Y sky130_fd_sc_hd__o21ai_1
X_1273_ _1566_/A _1566_/B _1273_/C VGND VGND VDPWR VDPWR _1389_/A sky130_fd_sc_hd__or3_1
XFILLER_36_255 VGND VGND VDPWR VDPWR sky130_fd_sc_hd__decap_3
XFILLER_51_214 VGND VGND VDPWR VDPWR sky130_fd_sc_hd__decap_3
Xwire15 wire15/A VGND VGND VDPWR VDPWR wire15/X sky130_fd_sc_hd__buf_2
XTAP_TAPCELL_ROW_61_264 VGND VDPWR sky130_fd_sc_hd__tapvpwrvgnd_1
X_1609_ _1609_/A _1610_/B _1610_/C VGND VGND VDPWR VDPWR _1609_/Y sky130_fd_sc_hd__nor3_1
XTAP_TAPCELL_ROW_52_220 VGND VDPWR sky130_fd_sc_hd__tapvpwrvgnd_1
XFILLER_10_188 VGND VGND VDPWR VDPWR sky130_fd_sc_hd__decap_3
XFILLER_33_236 VGND VGND VDPWR VDPWR sky130_fd_sc_hd__fill_2
XTAP_TAPCELL_ROW_75_334 VGND VDPWR sky130_fd_sc_hd__tapvpwrvgnd_1
X_1960_ _1960_/A _1960_/B VGND VGND VDPWR VDPWR _2189_/D sky130_fd_sc_hd__nor2_1
X_1891_ _2183_/Q _1861_/B _1890_/Y VGND VGND VDPWR VDPWR _1891_/Y sky130_fd_sc_hd__a21boi_1
XTAP_TAPCELL_ROW_34_2_2_152 VGND VDPWR sky130_fd_sc_hd__tapvpwrvgnd_1
X_1325_ _1660_/A1 _1635_/B _1099_/Y _1324_/Y _1364_/A VGND VGND VDPWR VDPWR _1327_/A
+ sky130_fd_sc_hd__a221oi_1
X_1256_ _1271_/A _1256_/B VGND VGND VDPWR VDPWR _1263_/A sky130_fd_sc_hd__xnor2_1
XFILLER_24_203 VGND VGND VDPWR VDPWR sky130_fd_sc_hd__fill_1
X_1187_ _1294_/B _1401_/A _1401_/B _1187_/D VGND VGND VDPWR VDPWR _1188_/B sky130_fd_sc_hd__nand4b_1
XFILLER_15_203 VGND VGND VDPWR VDPWR sky130_fd_sc_hd__fill_1
XFILLER_15_225 VGND VGND VDPWR VDPWR sky130_fd_sc_hd__decap_3
Xu_sub.u_psram.u_cg_sck.u_icg delaybuf_13_clk/X _2053_/B VGND VGND VDPWR VDPWR _2314_/A
+ sky130_fd_sc_hd__dlclkp_1
XFILLER_65_103 VGND VGND VDPWR VDPWR sky130_fd_sc_hd__fill_2
XFILLER_65_125 VGND VGND VDPWR VDPWR sky130_fd_sc_hd__decap_3
X_1110_ _1848_/B _2232_/Q VGND VGND VDPWR VDPWR _1716_/B sky130_fd_sc_hd__and2_1
X_2090_ _2303_/Q _2090_/B VGND VGND VDPWR VDPWR _2090_/X sky130_fd_sc_hd__xor2_1
X_1041_ _2212_/Q VGND VGND VDPWR VDPWR _2076_/A sky130_fd_sc_hd__inv_1
X_1943_ wire2/X _1943_/B VGND VGND VDPWR VDPWR _1943_/Y sky130_fd_sc_hd__nand2_1
X_1874_ _1874_/A1 _1871_/Y _1872_/X wire86/X VGND VGND VDPWR VDPWR _1874_/X sky130_fd_sc_hd__o31a_1
XTAP_TAPCELL_ROW_41_1_1_159 VGND VDPWR sky130_fd_sc_hd__tapvpwrvgnd_1
XFILLER_56_103 VGND VGND VDPWR VDPWR sky130_fd_sc_hd__fill_2
XFILLER_71_128 VGND VGND VDPWR VDPWR sky130_fd_sc_hd__decap_3
X_2288_ _2289_/CLK _2288_/D VGND VGND VDPWR VDPWR hold28/A sky130_fd_sc_hd__dfxtp_1
Xu_sub.u_core.u_regfile.g_nibsel\[4\].g_nib\[3\].u_m2 u_sub.u_core.u_regfile.g_nibsel\[4\].g_nib\[3\].u_lo/X
+ u_sub.u_core.u_regfile.g_nibsel\[4\].g_nib\[3\].u_hi/X max_cap1/X VGND VGND VDPWR
+ VDPWR u_sub.u_core.u_regfile.g_port\[3\].u_b/A3 sky130_fd_sc_hd__mux2_1
X_1308_ _1313_/A _1309_/B VGND VGND VDPWR VDPWR _1308_/X sky130_fd_sc_hd__and2_1
X_1239_ _1232_/A _1541_/A _1167_/C _1192_/Y _1128_/B VGND VGND VDPWR VDPWR _1566_/B
+ sky130_fd_sc_hd__a32o_1
XFILLER_69_13 VGND VGND VDPWR VDPWR sky130_fd_sc_hd__decap_3
XFILLER_69_35 VGND VGND VDPWR VDPWR sky130_fd_sc_hd__decap_3
XFILLER_47_103 VGND VGND VDPWR VDPWR sky130_fd_sc_hd__decap_3
Xclkbuf_1_0__f_u_sub.u_core.pc_gclk clkbuf_0_u_sub.u_core.pc_gclk/X VGND VGND VDPWR
+ VDPWR _2257_/CLK sky130_fd_sc_hd__clkbuf_2
XFILLER_47_169 VGND VGND VDPWR VDPWR sky130_fd_sc_hd__fill_1
XFILLER_62_106 VGND VGND VDPWR VDPWR sky130_fd_sc_hd__fill_1
XFILLER_62_117 VGND VGND VDPWR VDPWR sky130_fd_sc_hd__decap_3
XFILLER_70_150 VGND VGND VDPWR VDPWR sky130_fd_sc_hd__fill_1
X_1590_ _1590_/A _1610_/B VGND VGND VDPWR VDPWR _1601_/B sky130_fd_sc_hd__nor2_1
XFILLER_38_103 VGND VGND VDPWR VDPWR sky130_fd_sc_hd__fill_1
XFILLER_53_128 VGND VGND VDPWR VDPWR sky130_fd_sc_hd__fill_1
X_2211_ clkload8/A _2211_/D VGND VGND VDPWR VDPWR _2211_/Q sky130_fd_sc_hd__dfxtp_1
X_2142_ clkload4/A _2142_/D VGND VGND VDPWR VDPWR _2142_/Q sky130_fd_sc_hd__dfxtp_1
X_2073_ _2211_/Q _2088_/A _2123_/A VGND VGND VDPWR VDPWR _2073_/Y sky130_fd_sc_hd__o21ai_1
XFILLER_61_183 VGND VGND VDPWR VDPWR sky130_fd_sc_hd__decap_3
XTAP_TAPCELL_ROW_48_197 VGND VDPWR sky130_fd_sc_hd__tapvpwrvgnd_1
X_1926_ _1904_/A _1884_/Y _1925_/Y VGND VGND VDPWR VDPWR _1926_/Y sky130_fd_sc_hd__a21oi_1
X_1857_ _2211_/Q _1914_/S VGND VGND VDPWR VDPWR _1857_/Y sky130_fd_sc_hd__nand2b_1
X_1788_ _1783_/B _1785_/Y _1787_/Y VGND VGND VDPWR VDPWR _2144_/D sky130_fd_sc_hd__a21oi_1
XFILLER_69_261 VGND VGND VDPWR VDPWR sky130_fd_sc_hd__fill_1
XFILLER_44_128 VGND VGND VDPWR VDPWR sky130_fd_sc_hd__decap_3
XFILLER_52_150 VGND VGND VDPWR VDPWR sky130_fd_sc_hd__decap_3
XFILLER_71_25 VGND VGND VDPWR VDPWR sky130_fd_sc_hd__decap_3
XFILLER_71_47 VGND VGND VDPWR VDPWR sky130_fd_sc_hd__decap_3
XFILLER_71_69 VGND VGND VDPWR VDPWR sky130_fd_sc_hd__fill_2
Xhold60 hold60/A VGND VGND VDPWR VDPWR hold60/X sky130_fd_sc_hd__dlygate4sd3_1
Xu_sub.u_core.u_regfile.g_port\[0\].u_za u_sub.u_core.u_regfile.g_port\[0\].u_a/X
+ _1189_/C VGND VGND VDPWR VDPWR _1828_/A1 sky130_fd_sc_hd__and2_1
XFILLER_28_191 VGND VGND VDPWR VDPWR sky130_fd_sc_hd__decap_3
XFILLER_43_150 VGND VGND VDPWR VDPWR sky130_fd_sc_hd__decap_3
XFILLER_43_194 VGND VGND VDPWR VDPWR sky130_fd_sc_hd__decap_3
XANTENNA_2 ui_in[2] VGND VGND VDPWR VDPWR sky130_fd_sc_hd__diode_2
X_1711_ _1716_/B _1275_/Y _1710_/Y VGND VGND VDPWR VDPWR _2271_/D sky130_fd_sc_hd__a21oi_1
X_1642_ _1633_/B _1853_/C _1633_/Y VGND VGND VDPWR VDPWR wire76/A sky130_fd_sc_hd__o21ai_1
XFILLER_58_209 VGND VGND VDPWR VDPWR sky130_fd_sc_hd__fill_2
X_1573_ wire85/X _1573_/B VGND VGND VDPWR VDPWR _1574_/B sky130_fd_sc_hd__xnor2_1
XFILLER_19_191 VGND VGND VDPWR VDPWR sky130_fd_sc_hd__decap_3
XFILLER_41_109 VGND VGND VDPWR VDPWR sky130_fd_sc_hd__decap_3
XFILLER_66_242 VGND VGND VDPWR VDPWR sky130_fd_sc_hd__fill_1
X_2125_ _2125_/A _2125_/B _2125_/C VGND VGND VDPWR VDPWR _2178_/D sky130_fd_sc_hd__nor3_1
X_2056_ _2291_/D _2002_/A _2015_/B _2055_/Y VGND VGND VDPWR VDPWR _2207_/D sky130_fd_sc_hd__a31oi_1
XFILLER_34_183 VGND VGND VDPWR VDPWR sky130_fd_sc_hd__fill_2
X_1909_ _2210_/Q _1914_/S _1908_/Y VGND VGND VDPWR VDPWR _1909_/Y sky130_fd_sc_hd__a21oi_1
XFILLER_66_69 VGND VGND VDPWR VDPWR sky130_fd_sc_hd__fill_2
XFILLER_40_120 VGND VGND VDPWR VDPWR sky130_fd_sc_hd__decap_3
XTAP_TAPCELL_ROW_67_292 VGND VDPWR sky130_fd_sc_hd__tapvpwrvgnd_1
XFILLER_63_245 VGND VGND VDPWR VDPWR sky130_fd_sc_hd__decap_3
XFILLER_68_1 VGND VGND VDPWR VDPWR sky130_fd_sc_hd__fill_2
X_1625_ _1141_/A _1141_/B _1120_/C _1399_/A VGND VGND VDPWR VDPWR _1627_/C sky130_fd_sc_hd__o31ai_1
X_1556_ _2231_/Q _1563_/B VGND VGND VDPWR VDPWR _1561_/A sky130_fd_sc_hd__nand2_1
X_1487_ _2313_/A _1488_/B _1488_/C VGND VGND VDPWR VDPWR _2015_/B sky130_fd_sc_hd__and3_1
X_2108_ _2220_/Q _2106_/A _2107_/Y VGND VGND VDPWR VDPWR _2220_/D sky130_fd_sc_hd__a21oi_1
X_2039_ wire67/X _2006_/X _2037_/Y _2038_/Y VGND VGND VDPWR VDPWR _2039_/Y sky130_fd_sc_hd__a22oi_1
XPHY_EDGE_ROW_70_Left_129 VGND VDPWR sky130_fd_sc_hd__tapvpwrvgnd_1
XFILLER_42_93 VGND VGND VDPWR VDPWR sky130_fd_sc_hd__decap_3
XPHY_EDGE_ROW_32_2_2_Right_51 VGND VDPWR sky130_fd_sc_hd__tapvpwrvgnd_1
X_1410_ _1521_/A _2002_/A _1855_/B VGND VGND VDPWR VDPWR _1488_/B sky130_fd_sc_hd__nand3_1
XFILLER_36_201 VGND VGND VDPWR VDPWR sky130_fd_sc_hd__decap_3
X_1341_ _1208_/B _1340_/Y _1211_/Y VGND VGND VDPWR VDPWR _1341_/Y sky130_fd_sc_hd__a21oi_1
X_1272_ _1266_/B _1271_/Y _1269_/Y VGND VGND VDPWR VDPWR _1272_/Y sky130_fd_sc_hd__a21oi_1
XFILLER_36_267 VGND VGND VDPWR VDPWR sky130_fd_sc_hd__fill_2
XTAP_TAPCELL_ROW_61_265 VGND VDPWR sky130_fd_sc_hd__tapvpwrvgnd_1
X_1608_ _1608_/A _1610_/C VGND VGND VDPWR VDPWR _1608_/Y sky130_fd_sc_hd__nor2_1
X_1539_ _1539_/A _1541_/C VGND VGND VDPWR VDPWR _1539_/Y sky130_fd_sc_hd__nand2_1
XTAP_TAPCELL_ROW_52_221 VGND VDPWR sky130_fd_sc_hd__tapvpwrvgnd_1
XTAP_TAPCELL_ROW_75_335 VGND VDPWR sky130_fd_sc_hd__tapvpwrvgnd_1
XFILLER_41_281 VGND VGND VDPWR VDPWR sky130_fd_sc_hd__fill_2
X_1890_ _1614_/A _1890_/A2 wire81/X VGND VGND VDPWR VDPWR _1890_/Y sky130_fd_sc_hd__o21ai_1
XFILLER_68_101 VGND VGND VDPWR VDPWR sky130_fd_sc_hd__decap_3
XFILLER_68_123 VGND VGND VDPWR VDPWR sky130_fd_sc_hd__fill_1
X_1324_ _1324_/A _1324_/B VGND VGND VDPWR VDPWR _1324_/Y sky130_fd_sc_hd__nand2_1
X_1255_ _1271_/A _1255_/B _1255_/C VGND VGND VDPWR VDPWR _1255_/Y sky130_fd_sc_hd__nor3_1
X_1186_ _1187_/D _1062_/Y _1401_/B _1401_/C VGND VGND VDPWR VDPWR _1478_/A sky130_fd_sc_hd__a22oi_1
XFILLER_24_215 VGND VGND VDPWR VDPWR sky130_fd_sc_hd__fill_1
XFILLER_30_218 VGND VGND VDPWR VDPWR sky130_fd_sc_hd__fill_2
XTAP_TAPCELL_ROW_80_360 VGND VDPWR sky130_fd_sc_hd__tapvpwrvgnd_1
XFILLER_65_137 VGND VGND VDPWR VDPWR sky130_fd_sc_hd__fill_1
XFILLER_65_148 VGND VGND VDPWR VDPWR sky130_fd_sc_hd__fill_2
Xmax_cap3 _1632_/Y VGND VGND VDPWR VDPWR max_cap3/X sky130_fd_sc_hd__buf_6
X_1942_ _2189_/Q _1951_/B VGND VGND VDPWR VDPWR _1943_/B sky130_fd_sc_hd__nand2_1
XTAP_TAPCELL_ROW_38_2_2_154 VGND VDPWR sky130_fd_sc_hd__tapvpwrvgnd_1
X_1873_ _1871_/Y _1872_/X _1874_/A1 VGND VGND VDPWR VDPWR _1873_/Y sky130_fd_sc_hd__o21ai_1
XFILLER_56_115 VGND VGND VDPWR VDPWR sky130_fd_sc_hd__decap_3
XFILLER_71_107 VGND VGND VDPWR VDPWR sky130_fd_sc_hd__decap_3
X_2287_ _2290_/CLK _2287_/D VGND VGND VDPWR VDPWR hold27/A sky130_fd_sc_hd__dfxtp_1
X_1307_ _1307_/A _1313_/B VGND VGND VDPWR VDPWR _1309_/B sky130_fd_sc_hd__xnor2_1
X_1238_ _1241_/A _1241_/B _1241_/C VGND VGND VDPWR VDPWR _1566_/A sky130_fd_sc_hd__nor3_1
X_1169_ _1128_/B _1541_/B _1167_/Y _1168_/Y VGND VGND VDPWR VDPWR _1201_/B sky130_fd_sc_hd__a211oi_1
XFILLER_47_115 VGND VGND VDPWR VDPWR sky130_fd_sc_hd__decap_3
XFILLER_43_343 VGND VGND VDPWR VDPWR sky130_fd_sc_hd__fill_2
XFILLER_55_181 VGND VGND VDPWR VDPWR sky130_fd_sc_hd__fill_1
XFILLER_70_162 VGND VGND VDPWR VDPWR sky130_fd_sc_hd__fill_2
XFILLER_7_222 VGND VGND VDPWR VDPWR sky130_fd_sc_hd__fill_1
XFILLER_7_233 VGND VGND VDPWR VDPWR sky130_fd_sc_hd__decap_3
XFILLER_59_91 VGND VGND VDPWR VDPWR sky130_fd_sc_hd__decap_3
X_2210_ clkload8/A _2210_/D VGND VGND VDPWR VDPWR _2210_/Q sky130_fd_sc_hd__dfxtp_1
XTAP_TAPCELL_ROW_48_198 VGND VDPWR sky130_fd_sc_hd__tapvpwrvgnd_1
X_2141_ clkload3/A _2141_/D VGND VGND VDPWR VDPWR _2141_/Q sky130_fd_sc_hd__dfxtp_1
X_2072_ _2076_/B _2072_/B VGND VGND VDPWR VDPWR _2092_/B sky130_fd_sc_hd__nand2_1
XFILLER_61_140 VGND VGND VDPWR VDPWR sky130_fd_sc_hd__decap_3
XFILLER_61_162 VGND VGND VDPWR VDPWR sky130_fd_sc_hd__fill_1
X_1925_ _1904_/A _1877_/X _1885_/A VGND VGND VDPWR VDPWR _1925_/Y sky130_fd_sc_hd__o21ai_1
XPHY_EDGE_ROW_29_2_2_Right_48 VGND VDPWR sky130_fd_sc_hd__tapvpwrvgnd_1
X_1856_ _1856_/A1 _1854_/B _1854_/Y _1855_/Y VGND VGND VDPWR VDPWR _1856_/Y sky130_fd_sc_hd__o22ai_1
X_1787_ _2123_/A _1789_/C VGND VGND VDPWR VDPWR _1787_/Y sky130_fd_sc_hd__nand2_1
XFILLER_52_140 VGND VGND VDPWR VDPWR sky130_fd_sc_hd__decap_3
XFILLER_52_173 VGND VGND VDPWR VDPWR sky130_fd_sc_hd__decap_3
XFILLER_71_59 VGND VGND VDPWR VDPWR sky130_fd_sc_hd__decap_3
Xu_sub.u_core.u_regfile.g_port\[0\].u_zb u_sub.u_core.u_regfile.g_port\[0\].u_b/X
+ _1181_/X VGND VGND VDPWR VDPWR wire70/A sky130_fd_sc_hd__and2_1
XFILLER_35_118 VGND VGND VDPWR VDPWR sky130_fd_sc_hd__decap_3
Xhold50 hold50/A VGND VGND VDPWR VDPWR hold50/X sky130_fd_sc_hd__dlygate4sd3_1
Xhold61 hold61/A VGND VGND VDPWR VDPWR hold61/X sky130_fd_sc_hd__dlygate4sd3_1
XANTENNA_3 ui_in[3] VGND VGND VDPWR VDPWR sky130_fd_sc_hd__diode_2
X_1710_ _2259_/Q _1716_/B VGND VGND VDPWR VDPWR _1710_/Y sky130_fd_sc_hd__nor2_1
X_1641_ wire85/A _1641_/B VGND VGND VDPWR VDPWR _1853_/C sky130_fd_sc_hd__xnor2_1
X_1572_ _1572_/A _1578_/A VGND VGND VDPWR VDPWR _1573_/B sky130_fd_sc_hd__nand2_1
XFILLER_66_254 VGND VGND VDPWR VDPWR sky130_fd_sc_hd__decap_3
X_2124_ _2125_/A _2124_/B VGND VGND VDPWR VDPWR _2177_/D sky130_fd_sc_hd__nor2_1
X_2055_ _2291_/D _2015_/B _2207_/Q VGND VGND VDPWR VDPWR _2055_/Y sky130_fd_sc_hd__a21oi_1
X_1908_ _1914_/S _2214_/Q VGND VGND VDPWR VDPWR _1908_/Y sky130_fd_sc_hd__nor2b_1
X_1839_ _1621_/Y _1674_/B _1838_/Y VGND VGND VDPWR VDPWR _2161_/D sky130_fd_sc_hd__a21oi_1
XTAP_TAPCELL_ROW_67_293 VGND VDPWR sky130_fd_sc_hd__tapvpwrvgnd_1
XFILLER_40_132 VGND VGND VDPWR VDPWR sky130_fd_sc_hd__decap_3
XFILLER_40_176 VGND VGND VDPWR VDPWR sky130_fd_sc_hd__decap_3
XFILLER_40_198 VGND VGND VDPWR VDPWR sky130_fd_sc_hd__decap_3
Xu_sub.u_core.u_regfile.g_nibsel\[1\].g_nib\[0\].u_lo u_sub.u_core.u_regfile.g_word\[1\].g_byte\[0\].u_lat/Q0
+ u_sub.u_core.u_regfile.g_word\[1\].g_byte\[0\].u_lat/Q4 u_sub.u_core.u_regfile.g_word\[1\].g_byte\[1\].u_lat/Q0
+ u_sub.u_core.u_regfile.g_word\[1\].g_byte\[1\].u_lat/Q4 max_cap6/X max_cap3/X VGND
+ VGND VDPWR VDPWR u_sub.u_core.u_regfile.g_nibsel\[1\].g_nib\[0\].u_lo/X tg_mux4_x1
XFILLER_56_92 VGND VGND VDPWR VDPWR sky130_fd_sc_hd__fill_2
XFILLER_63_213 VGND VGND VDPWR VDPWR sky130_fd_sc_hd__fill_2
XPHY_EDGE_ROW_59_Right_78 VGND VDPWR sky130_fd_sc_hd__tapvpwrvgnd_1
X_1624_ _2169_/Q _1635_/B _1635_/C VGND VGND VDPWR VDPWR _1627_/B sky130_fd_sc_hd__nand3_1
X_1555_ _1527_/A _1564_/C _1554_/Y VGND VGND VDPWR VDPWR _2234_/D sky130_fd_sc_hd__o21ai_1
XFILLER_39_287 VGND VGND VDPWR VDPWR sky130_fd_sc_hd__fill_2
XPHY_EDGE_ROW_68_Right_87 VGND VDPWR sky130_fd_sc_hd__tapvpwrvgnd_1
X_2107_ _2220_/Q _2106_/A hold24/A VGND VGND VDPWR VDPWR _2107_/Y sky130_fd_sc_hd__o21ai_1
X_1486_ hold131/X _2291_/D _1486_/C _1486_/D VGND VGND VDPWR VDPWR _2001_/A sky130_fd_sc_hd__and4b_1
XPHY_EDGE_ROW_77_Right_96 VGND VDPWR sky130_fd_sc_hd__tapvpwrvgnd_1
X_2038_ _2204_/Q _2044_/B _2033_/Y _2036_/Y VGND VGND VDPWR VDPWR _2038_/Y sky130_fd_sc_hd__a31oi_1
XPHY_EDGE_ROW_13_2_2_Right_32 VGND VDPWR sky130_fd_sc_hd__tapvpwrvgnd_1
Xdelaybuf_0_clk delaybuf_1_clk/X VGND VGND VDPWR VDPWR delaybuf_0_clk/X sky130_fd_sc_hd__clkbuf_2
XFILLER_42_72 VGND VGND VDPWR VDPWR sky130_fd_sc_hd__decap_3
Xu_sub.u_core.u_regfile.g_word\[1\].g_byte\[1\].u_lat wire103/A wire102/X max_cap99/X
+ wire97/A wire95/A max_cap94/X wire92/X max_cap90/X u_sub.u_core.u_regfile.g_word\[1\].g_byte\[1\].u_lat/GATE
+ VGND VDPWR u_sub.u_core.u_regfile.g_word\[1\].g_byte\[1\].u_lat/Q0 u_sub.u_core.u_regfile.g_word\[1\].g_byte\[1\].u_lat/Q1
+ u_sub.u_core.u_regfile.g_word\[1\].g_byte\[1\].u_lat/Q2 u_sub.u_core.u_regfile.g_word\[1\].g_byte\[1\].u_lat/Q3
+ u_sub.u_core.u_regfile.g_word\[1\].g_byte\[1\].u_lat/Q4 u_sub.u_core.u_regfile.g_word\[1\].g_byte\[1\].u_lat/Q5
+ u_sub.u_core.u_regfile.g_word\[1\].g_byte\[1\].u_lat/Q6 u_sub.u_core.u_regfile.g_word\[1\].g_byte\[1\].u_lat/Q7
+ dlxtp8_x1
X_1340_ _1914_/S _1237_/A _1339_/Y VGND VGND VDPWR VDPWR _1340_/Y sky130_fd_sc_hd__a21oi_1
X_1271_ _1271_/A _1271_/B VGND VGND VDPWR VDPWR _1271_/Y sky130_fd_sc_hd__nand2_1
XTAP_TAPCELL_ROW_61_266 VGND VDPWR sky130_fd_sc_hd__tapvpwrvgnd_1
X_1607_ _1607_/A _1610_/C VGND VGND VDPWR VDPWR _1607_/Y sky130_fd_sc_hd__nor2_1
X_1538_ _1538_/A _1538_/B _1814_/A VGND VGND VDPWR VDPWR _1563_/B sky130_fd_sc_hd__nand3_1
X_1469_ _1476_/B _2121_/B VGND VGND VDPWR VDPWR _1965_/B sky130_fd_sc_hd__nand2_1
XFILLER_63_38 VGND VGND VDPWR VDPWR sky130_fd_sc_hd__decap_3
XFILLER_42_238 VGND VGND VDPWR VDPWR sky130_fd_sc_hd__fill_1
XTAP_TAPCELL_ROW_75_336 VGND VDPWR sky130_fd_sc_hd__tapvpwrvgnd_1
XFILLER_18_235 VGND VGND VDPWR VDPWR sky130_fd_sc_hd__fill_1
XFILLER_33_205 VGND VGND VDPWR VDPWR sky130_fd_sc_hd__decap_3
XFILLER_41_271 VGND VGND VDPWR VDPWR sky130_fd_sc_hd__decap_3
XFILLER_53_93 VGND VGND VDPWR VDPWR sky130_fd_sc_hd__fill_1
Xclkbuf_3_7__f_clk_regs clkbuf_0_clk_regs/X VGND VGND VDPWR VDPWR clkload9/A sky130_fd_sc_hd__clkbuf_2
X_1323_ hold58/A _1360_/B _1102_/Y hold54/A hold56/A _1376_/B VGND VGND VDPWR VDPWR
+ _1324_/B sky130_fd_sc_hd__a222oi_1
X_1254_ _1255_/B _1255_/C _1271_/A VGND VGND VDPWR VDPWR _1254_/Y sky130_fd_sc_hd__o21ai_1
X_1185_ _1187_/D _1294_/B VGND VGND VDPWR VDPWR _1401_/C sky130_fd_sc_hd__nor2_1
XFILLER_33_19 VGND VGND VDPWR VDPWR sky130_fd_sc_hd__fill_1
Xu_sub.u_core.u_regfile.g_word\[4\].g_byte\[1\].u_cg.u_icg clkbuf_leaf_3_clk/X _1603_/Y
+ VGND VGND VDPWR VDPWR u_sub.u_core.u_regfile.g_word\[4\].g_byte\[1\].u_lat/GATE
+ sky130_fd_sc_hd__dlclkp_1
Xu_sub.u_core.u_regfile.g_word\[2\].g_byte\[3\].u_cg.u_icg clkbuf_leaf_1_clk/X _1597_/X
+ VGND VGND VDPWR VDPWR u_sub.u_core.u_regfile.g_word\[2\].g_byte\[3\].u_lat/GATE
+ sky130_fd_sc_hd__dlclkp_1
XFILLER_15_216 VGND VGND VDPWR VDPWR sky130_fd_sc_hd__decap_3
XTAP_TAPCELL_ROW_72_317 VGND VDPWR sky130_fd_sc_hd__tapvpwrvgnd_1
XTAP_TAPCELL_ROW_80_361 VGND VDPWR sky130_fd_sc_hd__tapvpwrvgnd_1
XFILLER_65_116 VGND VGND VDPWR VDPWR sky130_fd_sc_hd__fill_2
Xmax_cap4 _1632_/Y VGND VGND VDPWR VDPWR max_cap4/X sky130_fd_sc_hd__buf_6
XFILLER_21_219 VGND VGND VDPWR VDPWR sky130_fd_sc_hd__fill_2
XFILLER_64_81 VGND VGND VDPWR VDPWR sky130_fd_sc_hd__decap_3
X_1941_ wire2/X _1938_/Y _1939_/Y _1940_/Y VGND VGND VDPWR VDPWR _2183_/D sky130_fd_sc_hd__a31oi_1
X_1872_ _1809_/Y _1832_/Y _1834_/Y _1871_/A VGND VGND VDPWR VDPWR _1872_/X sky130_fd_sc_hd__o211a_1
XFILLER_56_127 VGND VGND VDPWR VDPWR sky130_fd_sc_hd__decap_3
X_2286_ _2290_/CLK hold31/X VGND VGND VDPWR VDPWR hold37/A sky130_fd_sc_hd__dfxtp_1
X_1306_ wire69/X _1248_/C _1648_/S _1206_/Y _1305_/Y VGND VGND VDPWR VDPWR _1313_/B
+ sky130_fd_sc_hd__a32o_1
XFILLER_49_190 VGND VGND VDPWR VDPWR sky130_fd_sc_hd__decap_3
XFILLER_52_344 VGND VGND VDPWR VDPWR sky130_fd_sc_hd__fill_1
XFILLER_56_149 VGND VGND VDPWR VDPWR sky130_fd_sc_hd__decap_3
X_1099_ _1182_/A _1093_/Y _1635_/B _1638_/A VGND VGND VDPWR VDPWR _1099_/Y sky130_fd_sc_hd__a211oi_1
X_1237_ _1237_/A _1237_/B _1237_/C _1147_/A VGND VGND VDPWR VDPWR _1241_/C sky130_fd_sc_hd__nor4b_1
X_1168_ _1200_/A _1168_/B _1168_/C _1168_/D VGND VGND VDPWR VDPWR _1168_/Y sky130_fd_sc_hd__nor4_1
XFILLER_47_138 VGND VGND VDPWR VDPWR sky130_fd_sc_hd__fill_1
XFILLER_47_149 VGND VGND VDPWR VDPWR sky130_fd_sc_hd__fill_1
XFILLER_55_160 VGND VGND VDPWR VDPWR sky130_fd_sc_hd__fill_2
XFILLER_11_230 VGND VGND VDPWR VDPWR sky130_fd_sc_hd__decap_3
XFILLER_55_193 VGND VGND VDPWR VDPWR sky130_fd_sc_hd__fill_2
XFILLER_70_141 VGND VGND VDPWR VDPWR sky130_fd_sc_hd__decap_3
Xu_sub.u_core.u_regfile.g_nibsel\[2\].g_nib\[2\].u_m2 u_sub.u_core.u_regfile.g_nibsel\[2\].g_nib\[2\].u_lo/X
+ u_sub.u_core.u_regfile.g_nibsel\[2\].g_nib\[2\].u_hi/X max_cap75/X VGND VGND VDPWR
+ VDPWR u_sub.u_core.u_regfile.g_port\[2\].u_b/A1 sky130_fd_sc_hd__mux2_1
X_2140_ clkload3/A _2140_/D VGND VGND VDPWR VDPWR _2140_/Q sky130_fd_sc_hd__dfxtp_1
XFILLER_34_333 VGND VGND VDPWR VDPWR sky130_fd_sc_hd__decap_3
XFILLER_34_344 VGND VGND VDPWR VDPWR sky130_fd_sc_hd__fill_1
XTAP_TAPCELL_ROW_48_199 VGND VDPWR sky130_fd_sc_hd__tapvpwrvgnd_1
X_2071_ _2210_/Q _2209_/Q _2208_/Q _2211_/Q VGND VGND VDPWR VDPWR _2072_/B sky130_fd_sc_hd__a31o_1
X_1924_ _2230_/Q _1924_/B _1682_/A VGND VGND VDPWR VDPWR _1924_/Y sky130_fd_sc_hd__nor3b_1
X_1855_ _2154_/Q _1855_/B _1855_/C VGND VGND VDPWR VDPWR _1855_/Y sky130_fd_sc_hd__nor3_1
X_1786_ _2143_/Q _2144_/Q _1786_/C VGND VGND VDPWR VDPWR _1789_/C sky130_fd_sc_hd__nand3_1
X_2269_ _2273_/CLK hold42/X VGND VGND VDPWR VDPWR hold40/A sky130_fd_sc_hd__dfxtp_1
XFILLER_52_163 VGND VGND VDPWR VDPWR sky130_fd_sc_hd__fill_2
XFILLER_52_196 VGND VGND VDPWR VDPWR sky130_fd_sc_hd__decap_3
XFILLER_71_16 VGND VGND VDPWR VDPWR sky130_fd_sc_hd__decap_3
XFILLER_71_38 VGND VGND VDPWR VDPWR sky130_fd_sc_hd__decap_3
Xhold40 hold40/A VGND VGND VDPWR VDPWR hold40/X sky130_fd_sc_hd__dlygate4sd3_1
Xhold51 hold51/A VGND VGND VDPWR VDPWR hold51/X sky130_fd_sc_hd__dlygate4sd3_1
Xhold62 hold62/A VGND VGND VDPWR VDPWR hold62/X sky130_fd_sc_hd__dlygate4sd3_1
XFILLER_43_174 VGND VGND VDPWR VDPWR sky130_fd_sc_hd__decap_3
XANTENNA_4 uio_in[3] VGND VGND VDPWR VDPWR sky130_fd_sc_hd__diode_2
X_1640_ _1640_/A _1640_/B VGND VGND VDPWR VDPWR _1641_/B sky130_fd_sc_hd__xnor2_1
X_1571_ _1621_/B _1907_/A VGND VGND VDPWR VDPWR _1580_/B sky130_fd_sc_hd__nor2_1
XFILLER_66_233 VGND VGND VDPWR VDPWR sky130_fd_sc_hd__decap_3
X_2123_ _2123_/A _2123_/B _2123_/C VGND VGND VDPWR VDPWR _2227_/D sky130_fd_sc_hd__nand3_1
XTAP_TAPCELL_ROW_44_180 VGND VDPWR sky130_fd_sc_hd__tapvpwrvgnd_1
X_2054_ _2054_/A _2054_/B VGND VGND VDPWR VDPWR _2206_/D sky130_fd_sc_hd__nor2_1
X_1907_ _1907_/A _1907_/B _1907_/C VGND VGND VDPWR VDPWR _2125_/B sky130_fd_sc_hd__nor3_1
X_1838_ _2161_/Q _1842_/B VGND VGND VDPWR VDPWR _1838_/Y sky130_fd_sc_hd__nor2_1
X_1769_ _1769_/A _1803_/A VGND VGND VDPWR VDPWR _2138_/D sky130_fd_sc_hd__nor2b_1
XTAP_TAPCELL_ROW_67_294 VGND VDPWR sky130_fd_sc_hd__tapvpwrvgnd_1
XFILLER_40_100 VGND VGND VDPWR VDPWR sky130_fd_sc_hd__decap_3
XFILLER_40_188 VGND VGND VDPWR VDPWR sky130_fd_sc_hd__fill_2
XTAP_TAPCELL_ROW_58_250 VGND VDPWR sky130_fd_sc_hd__tapvpwrvgnd_1
X_1623_ _1631_/A _1853_/A _1616_/Y VGND VGND VDPWR VDPWR _1623_/Y sky130_fd_sc_hd__a21oi_2
X_1554_ _2229_/Q _1532_/B _2234_/Q VGND VGND VDPWR VDPWR _1554_/Y sky130_fd_sc_hd__o21ai_1
X_1485_ _2205_/Q _1480_/Y _1481_/Y _1482_/Y _1484_/Y VGND VGND VDPWR VDPWR _1486_/D
+ sky130_fd_sc_hd__o2111ai_1
.ends
