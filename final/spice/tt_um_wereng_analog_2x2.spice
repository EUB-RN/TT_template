* NGSPICE file created from tt_um_wereng_analog_2x2.ext - technology: sky130A

* Black-box entry subcircuit for sky130_fd_sc_hd__fill_1 abstract view
.subckt sky130_fd_sc_hd__fill_1 VGND VNB VPB VPWR
.ends

* Black-box entry subcircuit for sky130_fd_sc_hd__decap_3 abstract view
.subckt sky130_fd_sc_hd__decap_3 VGND VNB VPB VPWR
.ends

* Black-box entry subcircuit for sky130_fd_sc_hd__dfxtp_1 abstract view
.subckt sky130_fd_sc_hd__dfxtp_1 CLK D VGND VNB VPB VPWR Q
.ends

* Black-box entry subcircuit for sky130_fd_sc_hd__nor3_1 abstract view
.subckt sky130_fd_sc_hd__nor3_1 A B C VGND VNB VPB VPWR Y
.ends

* Black-box entry subcircuit for dlxtp8_x1 abstract view
.subckt dlxtp8_x1 D0 D1 D2 D3 D4 D5 D6 D7 GATE VGND VPWR Q0 Q1 Q2 Q3 Q4 Q5 Q6 Q7
.ends

* Black-box entry subcircuit for sky130_fd_sc_hd__clkbuf_2 abstract view
.subckt sky130_fd_sc_hd__clkbuf_2 A VGND VNB VPB VPWR X
.ends

* Black-box entry subcircuit for sky130_fd_sc_hd__fill_2 abstract view
.subckt sky130_fd_sc_hd__fill_2 VGND VNB VPB VPWR
.ends

* Black-box entry subcircuit for sky130_fd_sc_hd__a222oi_1 abstract view
.subckt sky130_fd_sc_hd__a222oi_1 A1 A2 B1 B2 C1 C2 VGND VNB VPB VPWR Y
.ends

* Black-box entry subcircuit for sky130_fd_sc_hd__nand2_1 abstract view
.subckt sky130_fd_sc_hd__nand2_1 A B VGND VNB VPB VPWR Y
.ends

* Black-box entry subcircuit for sky130_fd_sc_hd__nor2_1 abstract view
.subckt sky130_fd_sc_hd__nor2_1 A B VGND VNB VPB VPWR Y
.ends

* Black-box entry subcircuit for sky130_fd_sc_hd__o21ai_1 abstract view
.subckt sky130_fd_sc_hd__o21ai_1 A1 A2 B1 VGND VNB VPB VPWR Y
.ends

* Black-box entry subcircuit for sky130_fd_sc_hd__o41ai_1 abstract view
.subckt sky130_fd_sc_hd__o41ai_1 A1 A2 A3 A4 B1 VGND VNB VPB VPWR Y
.ends

* Black-box entry subcircuit for sky130_fd_sc_hd__dlclkp_1 abstract view
.subckt sky130_fd_sc_hd__dlclkp_1 CLK GATE VGND VNB VPB VPWR GCLK
.ends

* Black-box entry subcircuit for sky130_fd_sc_hd__a221o_1 abstract view
.subckt sky130_fd_sc_hd__a221o_1 A1 A2 B1 B2 C1 VGND VNB VPB VPWR X
.ends

* Black-box entry subcircuit for sky130_fd_sc_hd__xnor2_1 abstract view
.subckt sky130_fd_sc_hd__xnor2_1 A B VGND VNB VPB VPWR Y
.ends

* Black-box entry subcircuit for sky130_fd_sc_hd__o211ai_1 abstract view
.subckt sky130_fd_sc_hd__o211ai_1 A1 A2 B1 C1 VGND VNB VPB VPWR Y
.ends

* Black-box entry subcircuit for sky130_fd_sc_hd__tapvpwrvgnd_1 abstract view
.subckt sky130_fd_sc_hd__tapvpwrvgnd_1 VGND VPWR
.ends

* Black-box entry subcircuit for sky130_fd_sc_hd__buf_6 abstract view
.subckt sky130_fd_sc_hd__buf_6 A VGND VNB VPB VPWR X
.ends

* Black-box entry subcircuit for sky130_fd_sc_hd__mux4_2 abstract view
.subckt sky130_fd_sc_hd__mux4_2 A0 A1 A2 A3 S0 S1 VGND VNB VPB VPWR X
.ends

* Black-box entry subcircuit for sky130_fd_sc_hd__nor2b_1 abstract view
.subckt sky130_fd_sc_hd__nor2b_1 A B_N VGND VNB VPB VPWR Y
.ends

* Black-box entry subcircuit for sky130_fd_sc_hd__mux2_1 abstract view
.subckt sky130_fd_sc_hd__mux2_1 A0 A1 S VGND VNB VPB VPWR X
.ends

* Black-box entry subcircuit for sky130_fd_sc_hd__conb_1 abstract view
.subckt sky130_fd_sc_hd__conb_1 VGND VNB VPB VPWR HI LO
.ends

* Black-box entry subcircuit for sky130_fd_sc_hd__a21oi_1 abstract view
.subckt sky130_fd_sc_hd__a21oi_1 A1 A2 B1 VGND VNB VPB VPWR Y
.ends

* Black-box entry subcircuit for sky130_fd_sc_hd__nand2b_1 abstract view
.subckt sky130_fd_sc_hd__nand2b_1 A_N B VGND VNB VPB VPWR Y
.ends

* Black-box entry subcircuit for sky130_fd_sc_hd__nand3_1 abstract view
.subckt sky130_fd_sc_hd__nand3_1 A B C VGND VNB VPB VPWR Y
.ends

* Black-box entry subcircuit for sky130_fd_sc_hd__dlygate4sd3_1 abstract view
.subckt sky130_fd_sc_hd__dlygate4sd3_1 A VGND VNB VPB VPWR X
.ends

* Black-box entry subcircuit for sky130_fd_sc_hd__diode_2 abstract view
.subckt sky130_fd_sc_hd__diode_2 DIODE VGND VNB VPB VPWR
.ends

* Black-box entry subcircuit for sky130_fd_sc_hd__inv_1 abstract view
.subckt sky130_fd_sc_hd__inv_1 A VGND VNB VPB VPWR Y
.ends

* Black-box entry subcircuit for sky130_fd_sc_hd__a31oi_1 abstract view
.subckt sky130_fd_sc_hd__a31oi_1 A1 A2 A3 B1 VGND VNB VPB VPWR Y
.ends

* Black-box entry subcircuit for sky130_fd_sc_hd__o32a_1 abstract view
.subckt sky130_fd_sc_hd__o32a_1 A1 A2 A3 B1 B2 VGND VNB VPB VPWR X
.ends

* Black-box entry subcircuit for sky130_fd_sc_hd__a32o_1 abstract view
.subckt sky130_fd_sc_hd__a32o_1 A1 A2 A3 B1 B2 VGND VNB VPB VPWR X
.ends

* Black-box entry subcircuit for tg_mux4_x1 abstract view
.subckt tg_mux4_x1 A0 A1 A2 A3 S0 S1 VGND VNB VPB VPWR X
.ends

* Black-box entry subcircuit for sky130_fd_sc_hd__nor3b_1 abstract view
.subckt sky130_fd_sc_hd__nor3b_1 A B C_N VGND VNB VPB VPWR Y
.ends

* Black-box entry subcircuit for sky130_fd_sc_hd__buf_4 abstract view
.subckt sky130_fd_sc_hd__buf_4 A VGND VNB VPB VPWR X
.ends

* Black-box entry subcircuit for sky130_fd_sc_hd__o211a_1 abstract view
.subckt sky130_fd_sc_hd__o211a_1 A1 A2 B1 C1 VGND VNB VPB VPWR X
.ends

* Black-box entry subcircuit for sky130_fd_sc_hd__o22a_1 abstract view
.subckt sky130_fd_sc_hd__o22a_1 A1 A2 B1 B2 VGND VNB VPB VPWR X
.ends

* Black-box entry subcircuit for sky130_fd_sc_hd__clkbuf_4 abstract view
.subckt sky130_fd_sc_hd__clkbuf_4 A VGND VNB VPB VPWR X
.ends

* Black-box entry subcircuit for sky130_fd_sc_hd__a22oi_1 abstract view
.subckt sky130_fd_sc_hd__a22oi_1 A1 A2 B1 B2 VGND VNB VPB VPWR Y
.ends

* Black-box entry subcircuit for sky130_fd_sc_hd__o2bb2ai_1 abstract view
.subckt sky130_fd_sc_hd__o2bb2ai_1 A1_N A2_N B1 B2 VGND VNB VPB VPWR Y
.ends

* Black-box entry subcircuit for sky130_fd_sc_hd__and3_1 abstract view
.subckt sky130_fd_sc_hd__and3_1 A B C VGND VNB VPB VPWR X
.ends

* Black-box entry subcircuit for sky130_fd_sc_hd__a221oi_1 abstract view
.subckt sky130_fd_sc_hd__a221oi_1 A1 A2 B1 B2 C1 VGND VNB VPB VPWR Y
.ends

* Black-box entry subcircuit for sky130_fd_sc_hd__a211oi_1 abstract view
.subckt sky130_fd_sc_hd__a211oi_1 A1 A2 B1 C1 VGND VNB VPB VPWR Y
.ends

* Black-box entry subcircuit for sky130_fd_sc_hd__o21a_1 abstract view
.subckt sky130_fd_sc_hd__o21a_1 A1 A2 B1 VGND VNB VPB VPWR X
.ends

* Black-box entry subcircuit for sky130_fd_sc_hd__nor4_1 abstract view
.subckt sky130_fd_sc_hd__nor4_1 A B C D VGND VNB VPB VPWR Y
.ends

* Black-box entry subcircuit for sky130_fd_sc_hd__nand3b_1 abstract view
.subckt sky130_fd_sc_hd__nand3b_1 A_N B C VGND VNB VPB VPWR Y
.ends

* Black-box entry subcircuit for sky130_fd_sc_hd__o22ai_1 abstract view
.subckt sky130_fd_sc_hd__o22ai_1 A1 A2 B1 B2 VGND VNB VPB VPWR Y
.ends

* Black-box entry subcircuit for sky130_fd_sc_hd__a21o_1 abstract view
.subckt sky130_fd_sc_hd__a21o_1 A1 A2 B1 VGND VNB VPB VPWR X
.ends

* Black-box entry subcircuit for sky130_fd_sc_hd__or3_1 abstract view
.subckt sky130_fd_sc_hd__or3_1 A B C VGND VNB VPB VPWR X
.ends

* Black-box entry subcircuit for sky130_fd_sc_hd__o2111ai_1 abstract view
.subckt sky130_fd_sc_hd__o2111ai_1 A1 A2 B1 C1 D1 VGND VNB VPB VPWR Y
.ends

* Black-box entry subcircuit for sky130_fd_sc_hd__o21bai_1 abstract view
.subckt sky130_fd_sc_hd__o21bai_1 A1 A2 B1_N VGND VNB VPB VPWR Y
.ends

* Black-box entry subcircuit for sky130_fd_sc_hd__nor4bb_1 abstract view
.subckt sky130_fd_sc_hd__nor4bb_1 A B C_N D_N VGND VNB VPB VPWR Y
.ends

* Black-box entry subcircuit for sky130_fd_sc_hd__and2_1 abstract view
.subckt sky130_fd_sc_hd__and2_1 A B VGND VNB VPB VPWR X
.ends

* Black-box entry subcircuit for sky130_fd_sc_hd__a21boi_1 abstract view
.subckt sky130_fd_sc_hd__a21boi_1 A1 A2 B1_N VGND VNB VPB VPWR Y
.ends

* Black-box entry subcircuit for sky130_fd_sc_hd__inv_2 abstract view
.subckt sky130_fd_sc_hd__inv_2 A VGND VNB VPB VPWR Y
.ends

* Black-box entry subcircuit for sky130_fd_sc_hd__nand4_1 abstract view
.subckt sky130_fd_sc_hd__nand4_1 A B C D VGND VNB VPB VPWR Y
.ends

* Black-box entry subcircuit for sky130_fd_sc_hd__a31o_1 abstract view
.subckt sky130_fd_sc_hd__a31o_1 A1 A2 A3 B1 VGND VNB VPB VPWR X
.ends

* Black-box entry subcircuit for sky130_fd_sc_hd__dfrtp_1 abstract view
.subckt sky130_fd_sc_hd__dfrtp_1 CLK D RESET_B VGND VNB VPB VPWR Q
.ends

* Black-box entry subcircuit for sky130_fd_sc_hd__or4_1 abstract view
.subckt sky130_fd_sc_hd__or4_1 A B C D VGND VNB VPB VPWR X
.ends

* Black-box entry subcircuit for sky130_fd_sc_hd__and4_1 abstract view
.subckt sky130_fd_sc_hd__and4_1 A B C D VGND VNB VPB VPWR X
.ends

* Black-box entry subcircuit for sky130_fd_sc_hd__clkinv_16 abstract view
.subckt sky130_fd_sc_hd__clkinv_16 A VGND VNB VPB VPWR Y
.ends

* Black-box entry subcircuit for sky130_fd_sc_hd__a22o_1 abstract view
.subckt sky130_fd_sc_hd__a22o_1 A1 A2 B1 B2 VGND VNB VPB VPWR X
.ends

* Black-box entry subcircuit for sky130_fd_sc_hd__buf_2 abstract view
.subckt sky130_fd_sc_hd__buf_2 A VGND VNB VPB VPWR X
.ends

* Black-box entry subcircuit for sky130_fd_sc_hd__xor2_1 abstract view
.subckt sky130_fd_sc_hd__xor2_1 A B VGND VNB VPB VPWR X
.ends

* Black-box entry subcircuit for sky130_fd_sc_hd__or2_1 abstract view
.subckt sky130_fd_sc_hd__or2_1 A B VGND VNB VPB VPWR X
.ends

* Black-box entry subcircuit for sky130_fd_sc_hd__a32oi_1 abstract view
.subckt sky130_fd_sc_hd__a32oi_1 A1 A2 A3 B1 B2 VGND VNB VPB VPWR Y
.ends

* Black-box entry subcircuit for sky130_fd_sc_hd__nand4b_1 abstract view
.subckt sky130_fd_sc_hd__nand4b_1 A_N B C D VGND VNB VPB VPWR Y
.ends

* Black-box entry subcircuit for sky130_fd_sc_hd__buf_12 abstract view
.subckt sky130_fd_sc_hd__buf_12 A VGND VNB VPB VPWR X
.ends

* Black-box entry subcircuit for sky130_fd_sc_hd__o31a_1 abstract view
.subckt sky130_fd_sc_hd__o31a_1 A1 A2 A3 B1 VGND VNB VPB VPWR X
.ends

* Black-box entry subcircuit for sky130_fd_sc_hd__clkinv_4 abstract view
.subckt sky130_fd_sc_hd__clkinv_4 A VGND VNB VPB VPWR Y
.ends

* Black-box entry subcircuit for sky130_fd_sc_hd__clkinv_8 abstract view
.subckt sky130_fd_sc_hd__clkinv_8 A VGND VNB VPB VPWR Y
.ends

* Black-box entry subcircuit for sky130_fd_sc_hd__clkinv_1 abstract view
.subckt sky130_fd_sc_hd__clkinv_1 A VGND VNB VPB VPWR Y
.ends

* Black-box entry subcircuit for sky130_fd_sc_hd__inv_12 abstract view
.subckt sky130_fd_sc_hd__inv_12 A VGND VNB VPB VPWR Y
.ends

* Black-box entry subcircuit for island abstract view
.subckt island VGND VPWR axi_from[0] axi_from[1] axi_to[0] axi_to[1] cfg_d[0] cfg_d[1]
+ cfg_d[2] cfg_d[3] cfg_idx[0] cfg_idx[1] cfg_idx[2] cfg_idx[3] cfg_idx[4] cfg_idx[5]
+ cfg_we clk pad_in[0] pad_in[1] pad_io_in[0] pad_io_in[1] pad_io_oe[0] pad_io_oe[1]
+ pad_io_out[0] pad_io_out[1] pad_out[0] pad_out[1] rst_n
.ends

* Black-box entry subcircuit for sky130_fd_sc_hd__or4b_1 abstract view
.subckt sky130_fd_sc_hd__or4b_1 A B C D_N VGND VNB VPB VPWR X
.ends

* Black-box entry subcircuit for sky130_fd_sc_hd__inv_8 abstract view
.subckt sky130_fd_sc_hd__inv_8 A VGND VNB VPB VPWR Y
.ends

* Black-box entry subcircuit for sky130_fd_sc_hd__a2bb2oi_1 abstract view
.subckt sky130_fd_sc_hd__a2bb2oi_1 A1_N A2_N B1 B2 VGND VNB VPB VPWR Y
.ends

* Black-box entry subcircuit for sky130_fd_sc_hd__nor4b_1 abstract view
.subckt sky130_fd_sc_hd__nor4b_1 A B C D_N VGND VNB VPB VPWR Y
.ends

* Black-box entry subcircuit for sky130_fd_sc_hd__dlxtp_1 abstract view
.subckt sky130_fd_sc_hd__dlxtp_1 D GATE VGND VNB VPB VPWR Q
.ends

* Black-box entry subcircuit for sky130_fd_sc_hd__a2111oi_1 abstract view
.subckt sky130_fd_sc_hd__a2111oi_1 A1 A2 B1 C1 D1 VGND VNB VPB VPWR Y
.ends

* Black-box entry subcircuit for sky130_fd_sc_hd__a211o_1 abstract view
.subckt sky130_fd_sc_hd__a211o_1 A1 A2 B1 C1 VGND VNB VPB VPWR X
.ends

* Black-box entry subcircuit for sky130_fd_sc_hd__clkinvlp_4 abstract view
.subckt sky130_fd_sc_hd__clkinvlp_4 A VGND VNB VPB VPWR Y
.ends

* Black-box entry subcircuit for sky130_fd_sc_hd__dfstp_2 abstract view
.subckt sky130_fd_sc_hd__dfstp_2 CLK D SET_B VGND VNB VPB VPWR Q
.ends

* Black-box entry subcircuit for sky130_fd_sc_hd__o31ai_1 abstract view
.subckt sky130_fd_sc_hd__o31ai_1 A1 A2 A3 B1 VGND VNB VPB VPWR Y
.ends

* Black-box entry subcircuit for sky130_fd_sc_hd__o21ai_2 abstract view
.subckt sky130_fd_sc_hd__o21ai_2 A1 A2 B1 VGND VNB VPB VPWR Y
.ends

* Black-box entry subcircuit for sky130_fd_sc_hd__a41o_1 abstract view
.subckt sky130_fd_sc_hd__a41o_1 A1 A2 A3 A4 B1 VGND VNB VPB VPWR X
.ends

* Black-box entry subcircuit for sky130_fd_sc_hd__a311oi_1 abstract view
.subckt sky130_fd_sc_hd__a311oi_1 A1 A2 A3 B1 C1 VGND VNB VPB VPWR Y
.ends

* Black-box entry subcircuit for sky130_fd_sc_hd__and4b_1 abstract view
.subckt sky130_fd_sc_hd__and4b_1 A_N B C D VGND VNB VPB VPWR X
.ends

* Black-box entry subcircuit for sky130_fd_sc_hd__o221ai_1 abstract view
.subckt sky130_fd_sc_hd__o221ai_1 A1 A2 B1 B2 C1 VGND VNB VPB VPWR Y
.ends

* Black-box entry subcircuit for sky130_fd_sc_hd__clkbuf_8 abstract view
.subckt sky130_fd_sc_hd__clkbuf_8 A VGND VNB VPB VPWR X
.ends

* Black-box entry subcircuit for sky130_fd_sc_hd__o21ba_1 abstract view
.subckt sky130_fd_sc_hd__o21ba_1 A1 A2 B1_N VGND VNB VPB VPWR X
.ends

* Black-box entry subcircuit for top abstract view
.subckt top vdd vss clk dbg_busy dbg_outp dbg_start eoc irq rst_n s_axi_araddr s_axi_arready
+ s_axi_arvalid s_axi_awaddr s_axi_awready s_axi_awvalid s_axi_bready s_axi_bresp[0]
+ s_axi_bresp[1] s_axi_bvalid s_axi_rdata[0] s_axi_rdata[1] s_axi_rdata[2] s_axi_rdata[3]
+ s_axi_rdata[4] s_axi_rdata[5] s_axi_rdata[6] s_axi_rdata[7] s_axi_rready s_axi_rresp[0]
+ s_axi_rresp[1] s_axi_rvalid s_axi_wdata s_axi_wready s_axi_wstrb s_axi_wvalid sdo
+ sdo_valid start vin
.ends

* Black-box entry subcircuit for sky130_fd_sc_hd__buf_1 abstract view
.subckt sky130_fd_sc_hd__buf_1 A VGND VNB VPB VPWR X
.ends

* Black-box entry subcircuit for sky130_fd_sc_hd__o32ai_1 abstract view
.subckt sky130_fd_sc_hd__o32ai_1 A1 A2 A3 B1 B2 VGND VNB VPB VPWR Y
.ends

* Black-box entry subcircuit for sky130_fd_sc_hd__o2bb2a_1 abstract view
.subckt sky130_fd_sc_hd__o2bb2a_1 A1_N A2_N B1 B2 VGND VNB VPB VPWR X
.ends

* Black-box entry subcircuit for sky130_fd_sc_hd__buf_8 abstract view
.subckt sky130_fd_sc_hd__buf_8 A VGND VNB VPB VPWR X
.ends

* Black-box entry subcircuit for sky130_fd_sc_hd__and3b_1 abstract view
.subckt sky130_fd_sc_hd__and3b_1 A_N B C VGND VNB VPB VPWR X
.ends

* Black-box entry subcircuit for sky130_fd_sc_hd__nand4bb_1 abstract view
.subckt sky130_fd_sc_hd__nand4bb_1 A_N B_N C D VGND VNB VPB VPWR Y
.ends

.subckt tt_um_wereng_analog_2x2 VDPWR VGND clk ena rst_n ua[0] ua[1] ua[2] ua[3] ua[4]
+ ua[5] ua[6] ua[7] ui_in[0] ui_in[1] ui_in[2] ui_in[3] ui_in[4] ui_in[5] ui_in[6]
+ ui_in[7] uio_in[0] uio_in[1] uio_in[2] uio_in[3] uio_in[4] uio_in[5] uio_in[6] uio_in[7]
+ uio_oe[0] uio_oe[1] uio_oe[2] uio_oe[3] uio_oe[4] uio_oe[5] uio_oe[6] uio_oe[7]
+ uio_out[0] uio_out[1] uio_out[2] uio_out[3] uio_out[4] uio_out[5] uio_out[6] uio_out[7]
+ uo_out[0] uo_out[1] uo_out[2] uo_out[3] uo_out[4] uo_out[5] uo_out[6] uo_out[7]
XFILLER_54_203 VGND VGND VDPWR VDPWR sky130_fd_sc_hd__fill_1
XFILLER_54_236 VGND VGND VDPWR VDPWR sky130_fd_sc_hd__decap_3
X_2106_ clkload4/A _2106_/D VGND VGND VDPWR VDPWR _2106_/Q sky130_fd_sc_hd__dfxtp_1
X_2037_ _2037_/A _2037_/B _2037_/C VGND VGND VDPWR VDPWR _2043_/D sky130_fd_sc_hd__nor3_1
XFILLER_22_188 VGND VGND VDPWR VDPWR sky130_fd_sc_hd__decap_3
Xu_sub.u_core.u_regfile.g_word\[4\].g_byte\[3\].u_lat max_cap121/X max_cap119/X wire116/A
+ max_cap115/X wire112/A max_cap111/X max_cap109/X max_cap107/X u_sub.u_core.u_regfile.g_word\[4\].g_byte\[3\].u_lat/GATE
+ VGND VDPWR u_sub.u_core.u_regfile.g_word\[4\].g_byte\[3\].u_lat/Q0 u_sub.u_core.u_regfile.g_word\[4\].g_byte\[3\].u_lat/Q1
+ u_sub.u_core.u_regfile.g_word\[4\].g_byte\[3\].u_lat/Q2 u_sub.u_core.u_regfile.g_word\[4\].g_byte\[3\].u_lat/Q3
+ u_sub.u_core.u_regfile.g_word\[4\].g_byte\[3\].u_lat/Q4 u_sub.u_core.u_regfile.g_word\[4\].g_byte\[3\].u_lat/Q5
+ u_sub.u_core.u_regfile.g_word\[4\].g_byte\[3\].u_lat/Q6 u_sub.u_core.u_regfile.g_word\[4\].g_byte\[3\].u_lat/Q7
+ dlxtp8_x1
XFILLER_45_247 VGND VGND VDPWR VDPWR sky130_fd_sc_hd__fill_1
XFILLER_13_188 VGND VGND VDPWR VDPWR sky130_fd_sc_hd__decap_3
Xclkbuf_3_6__f_clk_regs clkbuf_0_clk_regs/X VGND VGND VDPWR VDPWR _2151_/CLK sky130_fd_sc_hd__clkbuf_2
XFILLER_36_225 VGND VGND VDPWR VDPWR sky130_fd_sc_hd__fill_2
X_1270_ hold60/A _1021_/Y _1744_/B hold55/A _1311_/B1 hold57/A VGND VGND VDPWR VDPWR
+ _1271_/B sky130_fd_sc_hd__a222oi_1
X_1606_ _1827_/C _1815_/B VGND VGND VDPWR VDPWR _1606_/Y sky130_fd_sc_hd__nand2_1
X_1537_ _1552_/A _1538_/B VGND VGND VDPWR VDPWR _1537_/Y sky130_fd_sc_hd__nor2_1
X_1468_ _1007_/Y _1469_/B _1467_/Y VGND VGND VDPWR VDPWR _2151_/D sky130_fd_sc_hd__o21ai_1
X_1399_ _1391_/Y _1395_/Y _1849_/A _1398_/Y wire86/X VGND VGND VDPWR VDPWR wire81/A
+ sky130_fd_sc_hd__o41ai_1
XFILLER_63_17 VGND VGND VDPWR VDPWR sky130_fd_sc_hd__fill_2
Xu_sub.u_timer.g_cmp\[1\].u_cg.u_icg delaybuf_3_clk/X _1555_/Y VGND VGND VDPWR VDPWR
+ clkbuf_0_u_sub.u_timer.g_cmp\[1\].g/A sky130_fd_sc_hd__dlclkp_1
XFILLER_37_73 VGND VGND VDPWR VDPWR sky130_fd_sc_hd__decap_3
XFILLER_37_84 VGND VGND VDPWR VDPWR sky130_fd_sc_hd__decap_3
XFILLER_41_283 VGND VGND VDPWR VDPWR sky130_fd_sc_hd__fill_1
X_1322_ _1539_/A _1169_/A _1185_/Y _1348_/A _1204_/B VGND VGND VDPWR VDPWR _1322_/X
+ sky130_fd_sc_hd__a221o_1
X_1253_ _1331_/A _1259_/B VGND VGND VDPWR VDPWR _1255_/B sky130_fd_sc_hd__xnor2_1
X_1184_ _1566_/A _1178_/Y _1183_/Y _2077_/Q VGND VGND VDPWR VDPWR _1184_/Y sky130_fd_sc_hd__o211ai_1
XPHY_EDGE_ROW_49_Left_108 VGND VDPWR sky130_fd_sc_hd__tapvpwrvgnd_1
XFILLER_59_103 VGND VGND VDPWR VDPWR sky130_fd_sc_hd__decap_3
XPHY_EDGE_ROW_58_Left_117 VGND VDPWR sky130_fd_sc_hd__tapvpwrvgnd_1
XFILLER_15_206 VGND VGND VDPWR VDPWR sky130_fd_sc_hd__decap_3
XPHY_EDGE_ROW_67_Left_126 VGND VDPWR sky130_fd_sc_hd__tapvpwrvgnd_1
XTAP_TAPCELL_ROW_72_318 VGND VDPWR sky130_fd_sc_hd__tapvpwrvgnd_1
XTAP_TAPCELL_ROW_80_362 VGND VDPWR sky130_fd_sc_hd__tapvpwrvgnd_1
XPHY_EDGE_ROW_76_Left_135 VGND VDPWR sky130_fd_sc_hd__tapvpwrvgnd_1
XFILLER_48_83 VGND VGND VDPWR VDPWR sky130_fd_sc_hd__fill_2
Xmax_cap5 wire83/A VGND VGND VDPWR VDPWR max_cap5/X sky130_fd_sc_hd__buf_6
X_1940_ hold52/A hold59/A hold43/A hold61/A _2151_/Q _2124_/Q VGND VGND VDPWR VDPWR
+ _1941_/B sky130_fd_sc_hd__mux4_2
X_1871_ _2110_/Q _1881_/D VGND VGND VDPWR VDPWR _1872_/B sky130_fd_sc_hd__nand2_1
X_1305_ _1305_/A _1305_/B VGND VGND VDPWR VDPWR _1833_/A sky130_fd_sc_hd__nand2_1
X_1236_ _1841_/S _1117_/B VGND VGND VDPWR VDPWR _1236_/Y sky130_fd_sc_hd__nor2b_1
XFILLER_64_150 VGND VGND VDPWR VDPWR sky130_fd_sc_hd__fill_1
Xclkbuf_0_u_sub.u_core.pc_gclk u_sub.u_core.u_cg_pc.u_icg/GCLK VGND VGND VDPWR VDPWR
+ clkbuf_0_u_sub.u_core.pc_gclk/X sky130_fd_sc_hd__clkbuf_2
Xu_sub.u_core.u_regfile.g_nibsel\[3\].g_nib\[0\].u_m2 u_sub.u_core.u_regfile.g_nibsel\[3\].g_nib\[0\].u_lo/X
+ ANTENNA_5/DIODE max_cap1/X VGND VGND VDPWR VDPWR u_sub.u_core.u_regfile.g_port\[0\].u_b/A2
+ sky130_fd_sc_hd__mux2_1
X_1167_ _1167_/A _1167_/B VGND VGND VDPWR VDPWR _1167_/Y sky130_fd_sc_hd__nor2_1
X_1098_ _1756_/B _1647_/B VGND VGND VDPWR VDPWR _1098_/Y sky130_fd_sc_hd__nand2_1
XFILLER_69_16 VGND VGND VDPWR VDPWR sky130_fd_sc_hd__decap_3
XFILLER_69_38 VGND VGND VDPWR VDPWR sky130_fd_sc_hd__decap_3
XFILLER_7_235 VGND VGND VDPWR VDPWR sky130_fd_sc_hd__fill_1
Xu_adc_19 VGND VGND VDPWR VDPWR u_adc_19/HI u_adc_19/LO sky130_fd_sc_hd__conb_1
X_2070_ clkload7/A _2070_/D VGND VGND VDPWR VDPWR _2070_/Q sky130_fd_sc_hd__dfxtp_1
XFILLER_61_186 VGND VGND VDPWR VDPWR sky130_fd_sc_hd__decap_3
X_1021_ _1566_/A _1791_/A VGND VGND VDPWR VDPWR _1021_/Y sky130_fd_sc_hd__nor2_1
XFILLER_61_197 VGND VGND VDPWR VDPWR sky130_fd_sc_hd__decap_3
X_1923_ hold58/A _1959_/A _1922_/Y VGND VGND VDPWR VDPWR _1923_/Y sky130_fd_sc_hd__a21oi_1
X_1854_ _1342_/Y _1854_/B VGND VGND VDPWR VDPWR _1854_/Y sky130_fd_sc_hd__nand2b_1
X_1785_ _2106_/Q wire7/X _1881_/B VGND VGND VDPWR VDPWR _1785_/Y sky130_fd_sc_hd__nand3_1
XFILLER_69_220 VGND VGND VDPWR VDPWR sky130_fd_sc_hd__fill_2
XFILLER_44_109 VGND VGND VDPWR VDPWR sky130_fd_sc_hd__decap_3
XFILLER_69_297 VGND VGND VDPWR VDPWR sky130_fd_sc_hd__fill_1
X_2199_ _2207_/CLK hold34/X VGND VGND VDPWR VDPWR hold25/A sky130_fd_sc_hd__dfxtp_1
X_1219_ _1343_/B _1587_/A VGND VGND VDPWR VDPWR _1221_/A sky130_fd_sc_hd__nor2_1
XFILLER_52_153 VGND VGND VDPWR VDPWR sky130_fd_sc_hd__fill_1
XFILLER_52_175 VGND VGND VDPWR VDPWR sky130_fd_sc_hd__decap_3
XFILLER_71_28 VGND VGND VDPWR VDPWR sky130_fd_sc_hd__decap_3
Xhold30 hold30/A VGND VGND VDPWR VDPWR hold30/X sky130_fd_sc_hd__dlygate4sd3_1
Xhold41 hold41/A VGND VGND VDPWR VDPWR hold41/X sky130_fd_sc_hd__dlygate4sd3_1
Xhold52 hold52/A VGND VGND VDPWR VDPWR hold52/X sky130_fd_sc_hd__dlygate4sd3_1
Xhold63 hold63/A VGND VGND VDPWR VDPWR hold63/X sky130_fd_sc_hd__dlygate4sd3_1
XFILLER_28_194 VGND VGND VDPWR VDPWR sky130_fd_sc_hd__fill_2
XFILLER_43_153 VGND VGND VDPWR VDPWR sky130_fd_sc_hd__fill_1
XANTENNA_5 ANTENNA_5/DIODE VGND VGND VDPWR VDPWR sky130_fd_sc_hd__diode_2
X_1570_ _1570_/A _1570_/B _1570_/C VGND VGND VDPWR VDPWR _1571_/B sky130_fd_sc_hd__nand3_1
X_2122_ clkload9/A _2122_/D VGND VGND VDPWR VDPWR uio_out[3] sky130_fd_sc_hd__dfxtp_1
X_2053_ clkload4/A _2053_/D VGND VGND VDPWR VDPWR _2053_/Q sky130_fd_sc_hd__dfxtp_1
XFILLER_19_194 VGND VGND VDPWR VDPWR sky130_fd_sc_hd__decap_3
XTAP_TAPCELL_ROW_44_181 VGND VDPWR sky130_fd_sc_hd__tapvpwrvgnd_1
X_1004_ _2076_/Q VGND VGND VDPWR VDPWR _1570_/A sky130_fd_sc_hd__inv_1
X_1906_ _2147_/Q _2114_/Q VGND VGND VDPWR VDPWR _1906_/Y sky130_fd_sc_hd__nand2_1
X_1837_ _1822_/X _1836_/Y _1562_/B VGND VGND VDPWR VDPWR _1837_/Y sky130_fd_sc_hd__a21oi_1
X_1768_ _1768_/A _1771_/A VGND VGND VDPWR VDPWR _1768_/Y sky130_fd_sc_hd__nand2_1
Xdelaybuf_10_clk delaybuf_9_clk/X VGND VGND VDPWR VDPWR delaybuf_11_clk/A sky130_fd_sc_hd__clkbuf_2
X_1699_ _2071_/Q _2070_/Q _2061_/Q _2062_/Q VGND VGND VDPWR VDPWR _1701_/A sky130_fd_sc_hd__a31oi_1
XTAP_TAPCELL_ROW_67_295 VGND VDPWR sky130_fd_sc_hd__tapvpwrvgnd_1
Xclkbuf_3_5__f_clk_regs clkbuf_0_clk_regs/X VGND VGND VDPWR VDPWR clkload9/A sky130_fd_sc_hd__clkbuf_2
XFILLER_48_201 VGND VGND VDPWR VDPWR sky130_fd_sc_hd__decap_3
XFILLER_48_245 VGND VGND VDPWR VDPWR sky130_fd_sc_hd__decap_3
XFILLER_48_267 VGND VGND VDPWR VDPWR sky130_fd_sc_hd__decap_3
XFILLER_48_278 VGND VGND VDPWR VDPWR sky130_fd_sc_hd__fill_1
XTAP_TAPCELL_ROW_58_251 VGND VDPWR sky130_fd_sc_hd__tapvpwrvgnd_1
XFILLER_68_4 VGND VGND VDPWR VDPWR sky130_fd_sc_hd__decap_3
X_1622_ _1997_/A _1841_/S _1881_/B _1620_/Y _1621_/Y VGND VGND VDPWR VDPWR _1622_/X
+ sky130_fd_sc_hd__o32a_1
XFILLER_39_234 VGND VGND VDPWR VDPWR sky130_fd_sc_hd__decap_3
X_1553_ _1553_/A _1553_/B VGND VGND VDPWR VDPWR _1553_/Y sky130_fd_sc_hd__nor2_1
X_1484_ _1646_/S _1504_/B _1483_/Y _1506_/B _2158_/Q VGND VGND VDPWR VDPWR _2158_/D
+ sky130_fd_sc_hd__a32o_1
XFILLER_39_245 VGND VGND VDPWR VDPWR sky130_fd_sc_hd__fill_1
XFILLER_39_278 VGND VGND VDPWR VDPWR sky130_fd_sc_hd__fill_2
XFILLER_54_215 VGND VGND VDPWR VDPWR sky130_fd_sc_hd__fill_1
X_2105_ clkload4/A _2105_/D VGND VGND VDPWR VDPWR _2105_/Q sky130_fd_sc_hd__dfxtp_1
X_2036_ _2145_/Q _2039_/B VGND VGND VDPWR VDPWR _2146_/D sky130_fd_sc_hd__nand2b_1
XFILLER_62_270 VGND VGND VDPWR VDPWR sky130_fd_sc_hd__fill_2
XFILLER_45_215 VGND VGND VDPWR VDPWR sky130_fd_sc_hd__decap_3
XFILLER_60_229 VGND VGND VDPWR VDPWR sky130_fd_sc_hd__fill_2
XTAP_TAPCELL_ROW_55_232 VGND VDPWR sky130_fd_sc_hd__tapvpwrvgnd_1
XFILLER_66_1 VGND VGND VDPWR VDPWR sky130_fd_sc_hd__fill_2
X_1605_ _1560_/A _1771_/B _1603_/Y VGND VGND VDPWR VDPWR _1815_/B sky130_fd_sc_hd__o21ai_1
X_1536_ _1551_/A _1538_/B VGND VGND VDPWR VDPWR _1536_/Y sky130_fd_sc_hd__nor2_1
XFILLER_27_204 VGND VGND VDPWR VDPWR sky130_fd_sc_hd__fill_1
XTAP_TAPCELL_ROW_69_302 VGND VDPWR sky130_fd_sc_hd__tapvpwrvgnd_1
X_1467_ _2149_/Q _1549_/A VGND VGND VDPWR VDPWR _1467_/Y sky130_fd_sc_hd__nor2_1
X_1398_ _2075_/Q _1723_/C VGND VGND VDPWR VDPWR _1398_/Y sky130_fd_sc_hd__nor2_1
XFILLER_50_251 VGND VGND VDPWR VDPWR sky130_fd_sc_hd__fill_2
XFILLER_63_29 VGND VGND VDPWR VDPWR sky130_fd_sc_hd__decap_3
X_2019_ _2222_/Q _2019_/B VGND VGND VDPWR VDPWR _2020_/D sky130_fd_sc_hd__xnor2_1
XFILLER_50_273 VGND VGND VDPWR VDPWR sky130_fd_sc_hd__decap_3
Xu_sub.u_core.u_regfile.g_nibsel\[3\].g_nib\[2\].u_hi u_sub.u_core.u_regfile.g_word\[3\].g_byte\[2\].u_lat/Q2
+ u_sub.u_core.u_regfile.g_word\[3\].g_byte\[2\].u_lat/Q6 u_sub.u_core.u_regfile.g_word\[3\].g_byte\[3\].u_lat/Q2
+ u_sub.u_core.u_regfile.g_word\[3\].g_byte\[3\].u_lat/Q6 max_cap4/X max_cap2/X VGND
+ VGND VDPWR VDPWR u_sub.u_core.u_regfile.g_nibsel\[3\].g_nib\[2\].u_hi/X tg_mux4_x1
XTAP_TAPCELL_ROW_12_2_2_141 VGND VDPWR sky130_fd_sc_hd__tapvpwrvgnd_1
X_1321_ _1321_/A _1321_/B _2077_/Q VGND VGND VDPWR VDPWR _1329_/A sky130_fd_sc_hd__nor3b_1
X_1252_ _1165_/Y _1244_/Y _1251_/Y _1109_/Y _2213_/D VGND VGND VDPWR VDPWR _1259_/B
+ sky130_fd_sc_hd__a32o_1
X_1183_ _1173_/Y _1182_/Y _1566_/A VGND VGND VDPWR VDPWR _1183_/Y sky130_fd_sc_hd__o21ai_1
XFILLER_59_115 VGND VGND VDPWR VDPWR sky130_fd_sc_hd__fill_2
XFILLER_59_137 VGND VGND VDPWR VDPWR sky130_fd_sc_hd__decap_3
X_1519_ _1566_/A _1521_/A _1517_/Y VGND VGND VDPWR VDPWR _1529_/A sky130_fd_sc_hd__o21ai_1
XFILLER_55_343 VGND VGND VDPWR VDPWR sky130_fd_sc_hd__fill_2
XPHY_EDGE_ROW_25_2_2_Right_44 VGND VDPWR sky130_fd_sc_hd__tapvpwrvgnd_1
XTAP_TAPCELL_ROW_72_319 VGND VDPWR sky130_fd_sc_hd__tapvpwrvgnd_1
XFILLER_15_218 VGND VGND VDPWR VDPWR sky130_fd_sc_hd__decap_3
XTAP_TAPCELL_ROW_80_363 VGND VDPWR sky130_fd_sc_hd__tapvpwrvgnd_1
XFILLER_2_188 VGND VGND VDPWR VDPWR sky130_fd_sc_hd__fill_2
XFILLER_65_118 VGND VGND VDPWR VDPWR sky130_fd_sc_hd__fill_1
XFILLER_58_170 VGND VGND VDPWR VDPWR sky130_fd_sc_hd__decap_3
Xmax_cap6 _1981_/Y VGND VGND VDPWR VDPWR _2021_/A1 sky130_fd_sc_hd__buf_4
X_1870_ _2104_/Q _1869_/A _1869_/Y _1729_/A VGND VGND VDPWR VDPWR _2104_/D sky130_fd_sc_hd__o211a_1
XFILLER_49_181 VGND VGND VDPWR VDPWR sky130_fd_sc_hd__fill_2
X_1304_ _1211_/A _1299_/Y _1301_/B _1337_/B VGND VGND VDPWR VDPWR _1305_/B sky130_fd_sc_hd__o22a_1
X_1235_ _1566_/A _1235_/B VGND VGND VDPWR VDPWR _1235_/Y sky130_fd_sc_hd__nor2_1
X_1166_ _1166_/A _1278_/B VGND VGND VDPWR VDPWR _1166_/Y sky130_fd_sc_hd__nand2_1
Xclkbuf_1_0__f_u_sub.u_timer.g_cmp\[0\].g clkbuf_0_u_sub.u_timer.g_cmp\[0\].g/X VGND
+ VGND VDPWR VDPWR _2219_/GATE sky130_fd_sc_hd__clkbuf_2
X_1097_ _1753_/A _1646_/S VGND VGND VDPWR VDPWR _1314_/B sky130_fd_sc_hd__nor2_1
XFILLER_69_28 VGND VGND VDPWR VDPWR sky130_fd_sc_hd__decap_3
X_1999_ _2021_/A1 _2018_/B _1998_/Y VGND VGND VDPWR VDPWR _2133_/D sky130_fd_sc_hd__a21oi_1
XFILLER_47_118 VGND VGND VDPWR VDPWR sky130_fd_sc_hd__decap_3
XFILLER_43_335 VGND VGND VDPWR VDPWR sky130_fd_sc_hd__decap_3
XFILLER_11_232 VGND VGND VDPWR VDPWR sky130_fd_sc_hd__decap_3
Xu_sub.u_core.u_cg_epc.u_icg clkload3/A _1421_/Y VGND VGND VDPWR VDPWR u_sub.u_core.u_cg_epc.u_icg/GCLK
+ sky130_fd_sc_hd__dlclkp_1
Xwire134 wire134/A VGND VGND VDPWR VDPWR _1057_/B sky130_fd_sc_hd__clkbuf_4
Xwire112 wire112/A VGND VGND VDPWR VDPWR wire112/X sky130_fd_sc_hd__buf_6
XFILLER_59_50 VGND VGND VDPWR VDPWR sky130_fd_sc_hd__fill_1
XFILLER_46_151 VGND VGND VDPWR VDPWR sky130_fd_sc_hd__decap_3
XFILLER_59_83 VGND VGND VDPWR VDPWR sky130_fd_sc_hd__fill_2
X_1020_ _2043_/B _2155_/Q VGND VGND VDPWR VDPWR _1421_/A sky130_fd_sc_hd__nand2_1
Xclkbuf_0_u_sub.u_core.epc_gclk u_sub.u_core.u_cg_epc.u_icg/GCLK VGND VGND VDPWR VDPWR
+ clkbuf_0_u_sub.u_core.epc_gclk/X sky130_fd_sc_hd__clkbuf_2
XFILLER_46_173 VGND VGND VDPWR VDPWR sky130_fd_sc_hd__decap_3
XFILLER_61_154 VGND VGND VDPWR VDPWR sky130_fd_sc_hd__fill_1
X_1922_ _1959_/A hold40/A VGND VGND VDPWR VDPWR _1922_/Y sky130_fd_sc_hd__nor2b_1
X_1853_ _2046_/A _2046_/B _2046_/C VGND VGND VDPWR VDPWR _2095_/D sky130_fd_sc_hd__nor3_1
X_1784_ _1784_/A1 _1429_/D _2075_/Q VGND VGND VDPWR VDPWR _1784_/Y sky130_fd_sc_hd__a21oi_1
XFILLER_37_184 VGND VGND VDPWR VDPWR sky130_fd_sc_hd__fill_2
XFILLER_37_195 VGND VGND VDPWR VDPWR sky130_fd_sc_hd__decap_3
X_2198_ _2207_/CLK hold28/X VGND VGND VDPWR VDPWR _2198_/Q sky130_fd_sc_hd__dfxtp_1
X_1218_ _1214_/B _1337_/B _1217_/Y _1211_/X VGND VGND VDPWR VDPWR _1587_/A sky130_fd_sc_hd__o211ai_1
X_1149_ _1010_/Y _1039_/Y _1376_/B VGND VGND VDPWR VDPWR _1149_/Y sky130_fd_sc_hd__a21oi_1
XFILLER_40_305 VGND VGND VDPWR VDPWR sky130_fd_sc_hd__fill_2
Xclkbuf_1_1__f_u_sub.u_core.epc_gclk clkbuf_0_u_sub.u_core.epc_gclk/X VGND VGND VDPWR
+ VDPWR _2207_/CLK sky130_fd_sc_hd__clkbuf_2
Xclkbuf_3_4__f_clk_regs clkbuf_0_clk_regs/X VGND VGND VDPWR VDPWR clkload8/A sky130_fd_sc_hd__clkbuf_2
XFILLER_4_206 VGND VGND VDPWR VDPWR sky130_fd_sc_hd__fill_1
XFILLER_4_228 VGND VGND VDPWR VDPWR sky130_fd_sc_hd__decap_3
Xhold20 hold21/A VGND VGND VDPWR VDPWR hold20/X sky130_fd_sc_hd__dlygate4sd3_1
Xhold31 hold31/A VGND VGND VDPWR VDPWR hold31/X sky130_fd_sc_hd__dlygate4sd3_1
Xhold42 hold42/A VGND VGND VDPWR VDPWR hold42/X sky130_fd_sc_hd__dlygate4sd3_1
Xhold53 hold53/A VGND VGND VDPWR VDPWR hold53/X sky130_fd_sc_hd__dlygate4sd3_1
Xhold64 hold64/A VGND VGND VDPWR VDPWR hold64/X sky130_fd_sc_hd__dlygate4sd3_1
XFILLER_43_176 VGND VGND VDPWR VDPWR sky130_fd_sc_hd__decap_3
XFILLER_45_52 VGND VGND VDPWR VDPWR sky130_fd_sc_hd__fill_2
XANTENNA_6 ui_in[1] VGND VGND VDPWR VDPWR sky130_fd_sc_hd__diode_2
XFILLER_66_202 VGND VGND VDPWR VDPWR sky130_fd_sc_hd__fill_2
X_1003_ _2151_/Q VGND VGND VDPWR VDPWR _1950_/A sky130_fd_sc_hd__inv_1
X_2121_ clkload9/A _2121_/D VGND VGND VDPWR VDPWR uio_out[2] sky130_fd_sc_hd__dfxtp_1
X_2052_ clkload4/A _2052_/D VGND VGND VDPWR VDPWR _2052_/Q sky130_fd_sc_hd__dfxtp_1
X_1905_ _2137_/Q _2112_/Q _1908_/B _2113_/Q VGND VGND VDPWR VDPWR _1911_/C sky130_fd_sc_hd__a22oi_1
X_1836_ _1594_/X _1607_/Y _1834_/Y _1835_/X VGND VGND VDPWR VDPWR _1836_/Y sky130_fd_sc_hd__o2bb2ai_1
X_1767_ _1771_/A _1823_/B _1766_/Y VGND VGND VDPWR VDPWR _2083_/D sky130_fd_sc_hd__o21ai_1
X_1698_ _1729_/A _1714_/B _1698_/C VGND VGND VDPWR VDPWR _2061_/D sky130_fd_sc_hd__and3_1
XFILLER_57_235 VGND VGND VDPWR VDPWR sky130_fd_sc_hd__decap_3
XTAP_TAPCELL_ROW_67_296 VGND VDPWR sky130_fd_sc_hd__tapvpwrvgnd_1
Xdelaybuf_3_clk u_adc/clk VGND VGND VDPWR VDPWR delaybuf_3_clk/X sky130_fd_sc_hd__clkbuf_2
XFILLER_48_224 VGND VGND VDPWR VDPWR sky130_fd_sc_hd__decap_3
XFILLER_63_205 VGND VGND VDPWR VDPWR sky130_fd_sc_hd__decap_3
Xu_sub.u_core.u_cg_wb_lo.u_icg clkload2/A _1414_/Y VGND VGND VDPWR VDPWR u_sub.u_core.u_cg_wb_lo.u_icg/GCLK
+ sky130_fd_sc_hd__dlclkp_1
X_1621_ _2129_/Q _1881_/B _1841_/S VGND VGND VDPWR VDPWR _1621_/Y sky130_fd_sc_hd__o21ai_1
X_1552_ _1552_/A _1553_/B VGND VGND VDPWR VDPWR _1552_/Y sky130_fd_sc_hd__nor2_1
X_2104_ clkload6/A _2104_/D VGND VGND VDPWR VDPWR _2104_/Q sky130_fd_sc_hd__dfxtp_1
X_1483_ wire89/A _1483_/B VGND VGND VDPWR VDPWR _1483_/Y sky130_fd_sc_hd__nor2_1
XFILLER_54_205 VGND VGND VDPWR VDPWR sky130_fd_sc_hd__decap_3
XTAP_TAPCELL_ROW_64_277 VGND VDPWR sky130_fd_sc_hd__tapvpwrvgnd_1
X_2035_ hold142/X hold21/A VGND VGND VDPWR VDPWR _2145_/D sky130_fd_sc_hd__nand2b_1
XPHY_EDGE_ROW_46_Right_65 VGND VDPWR sky130_fd_sc_hd__tapvpwrvgnd_1
X_1819_ _1834_/A _1819_/B VGND VGND VDPWR VDPWR _1819_/Y sky130_fd_sc_hd__nor2_1
XPHY_EDGE_ROW_55_Right_74 VGND VDPWR sky130_fd_sc_hd__tapvpwrvgnd_1
XTAP_TAPCELL_ROW_55_233 VGND VDPWR sky130_fd_sc_hd__tapvpwrvgnd_1
XPHY_EDGE_ROW_64_Right_83 VGND VDPWR sky130_fd_sc_hd__tapvpwrvgnd_1
XPHY_EDGE_ROW_73_Right_92 VGND VDPWR sky130_fd_sc_hd__tapvpwrvgnd_1
XTAP_TAPCELL_ROW_78_347 VGND VDPWR sky130_fd_sc_hd__tapvpwrvgnd_1
XFILLER_44_271 VGND VGND VDPWR VDPWR sky130_fd_sc_hd__fill_1
Xu_sub.u_core.u_regfile.g_nibsel\[4\].g_nib\[0\].u_hi u_sub.u_core.u_regfile.g_word\[4\].g_byte\[2\].u_lat/Q0
+ u_sub.u_core.u_regfile.g_word\[4\].g_byte\[2\].u_lat/Q4 u_sub.u_core.u_regfile.g_word\[4\].g_byte\[3\].u_lat/Q0
+ u_sub.u_core.u_regfile.g_word\[4\].g_byte\[3\].u_lat/Q4 max_cap5/X max_cap3/X VGND
+ VGND VDPWR VDPWR u_sub.u_core.u_regfile.g_nibsel\[4\].g_nib\[0\].u_hi/X tg_mux4_x1
XFILLER_59_1 VGND VGND VDPWR VDPWR sky130_fd_sc_hd__fill_2
X_1604_ _1006_/Y wire90/X _1599_/Y VGND VGND VDPWR VDPWR _1771_/B sky130_fd_sc_hd__o21ai_1
X_1535_ _1550_/A _1538_/B VGND VGND VDPWR VDPWR _1535_/Y sky130_fd_sc_hd__nor2_1
XTAP_TAPCELL_ROW_69_303 VGND VDPWR sky130_fd_sc_hd__tapvpwrvgnd_1
X_1466_ _1504_/B _1466_/B _1466_/C VGND VGND VDPWR VDPWR _1469_/B sky130_fd_sc_hd__nand3_1
X_1397_ _1397_/A _1653_/C VGND VGND VDPWR VDPWR _1849_/A sky130_fd_sc_hd__nand2_1
X_2018_ _2220_/Q _2018_/B VGND VGND VDPWR VDPWR _2020_/C sky130_fd_sc_hd__xnor2_1
X_2149__17 VGND VGND VDPWR VDPWR _2149__17/HI _2149_/D sky130_fd_sc_hd__conb_1
XFILLER_58_341 VGND VGND VDPWR VDPWR sky130_fd_sc_hd__decap_3
Xhold150 _2084_/Q VGND VGND VDPWR VDPWR _1768_/A sky130_fd_sc_hd__dlygate4sd3_1
XFILLER_53_74 VGND VGND VDPWR VDPWR sky130_fd_sc_hd__fill_2
Xu_sub.u_core.u_regfile.g_ir\[2\].u_cg.u_icg clkload0/A _1552_/Y VGND VGND VDPWR VDPWR
+ u_sub.u_core.u_regfile.g_ir\[2\].u_lat/GATE sky130_fd_sc_hd__dlclkp_1
X_1320_ _1841_/S _1167_/A _1242_/B _1319_/Y _1238_/Y VGND VGND VDPWR VDPWR _1321_/B
+ sky130_fd_sc_hd__a221oi_1
XFILLER_49_330 VGND VGND VDPWR VDPWR sky130_fd_sc_hd__fill_2
X_1251_ _1204_/B _1247_/Y _1250_/Y VGND VGND VDPWR VDPWR _1251_/Y sky130_fd_sc_hd__o21ai_1
X_1182_ _1174_/B _1170_/Y _1181_/Y _1168_/Y VGND VGND VDPWR VDPWR _1182_/Y sky130_fd_sc_hd__a211oi_1
XFILLER_24_219 VGND VGND VDPWR VDPWR sky130_fd_sc_hd__fill_1
X_1518_ _1566_/A _1521_/A _1517_/Y VGND VGND VDPWR VDPWR _1531_/A sky130_fd_sc_hd__o21a_1
X_1449_ _1747_/A _2155_/Q _2153_/Q _2157_/Q VGND VGND VDPWR VDPWR _1449_/Y sky130_fd_sc_hd__nor4_1
XFILLER_70_336 VGND VGND VDPWR VDPWR sky130_fd_sc_hd__decap_3
XTAP_TAPCELL_ROW_80_364 VGND VDPWR sky130_fd_sc_hd__tapvpwrvgnd_1
XFILLER_48_96 VGND VGND VDPWR VDPWR sky130_fd_sc_hd__decap_3
XTAP_TAPCELL_ROW_16_2_2_143 VGND VDPWR sky130_fd_sc_hd__tapvpwrvgnd_1
XFILLER_14_230 VGND VGND VDPWR VDPWR sky130_fd_sc_hd__decap_3
X_1303_ _1300_/A _1300_/B _1302_/Y VGND VGND VDPWR VDPWR _1305_/A sky130_fd_sc_hd__o21ai_1
XFILLER_49_171 VGND VGND VDPWR VDPWR sky130_fd_sc_hd__decap_3
XFILLER_64_141 VGND VGND VDPWR VDPWR sky130_fd_sc_hd__decap_3
X_1234_ _1121_/D _1242_/B _1841_/S VGND VGND VDPWR VDPWR _1234_/Y sky130_fd_sc_hd__nand3b_1
X_1165_ _1314_/B _1164_/Y _1110_/C VGND VGND VDPWR VDPWR _1165_/Y sky130_fd_sc_hd__a21oi_1
X_1096_ _1764_/A1 _1086_/X _1087_/Y _1095_/Y VGND VGND VDPWR VDPWR _1096_/Y sky130_fd_sc_hd__a22oi_1
Xclkbuf_3_3__f_clk_regs clkbuf_0_clk_regs/X VGND VGND VDPWR VDPWR clkload7/A sky130_fd_sc_hd__clkbuf_2
X_1998_ _2133_/Q _2021_/A1 _2039_/B VGND VGND VDPWR VDPWR _1998_/Y sky130_fd_sc_hd__o21ai_1
XFILLER_55_130 VGND VGND VDPWR VDPWR sky130_fd_sc_hd__decap_3
XFILLER_7_226 VGND VGND VDPWR VDPWR sky130_fd_sc_hd__fill_1
Xwire135 wire135/A VGND VGND VDPWR VDPWR _1458_/B sky130_fd_sc_hd__clkbuf_4
XFILLER_59_62 VGND VGND VDPWR VDPWR sky130_fd_sc_hd__decap_3
XFILLER_59_95 VGND VGND VDPWR VDPWR sky130_fd_sc_hd__fill_2
XFILLER_46_141 VGND VGND VDPWR VDPWR sky130_fd_sc_hd__fill_2
XFILLER_46_163 VGND VGND VDPWR VDPWR sky130_fd_sc_hd__fill_1
XFILLER_46_185 VGND VGND VDPWR VDPWR sky130_fd_sc_hd__fill_1
XFILLER_61_166 VGND VGND VDPWR VDPWR sky130_fd_sc_hd__decap_3
XFILLER_61_177 VGND VGND VDPWR VDPWR sky130_fd_sc_hd__decap_3
X_1921_ _1959_/A hold48/A _1920_/Y VGND VGND VDPWR VDPWR _1921_/Y sky130_fd_sc_hd__o21ai_1
X_1852_ _1852_/A _1852_/B VGND VGND VDPWR VDPWR _2046_/C sky130_fd_sc_hd__nor2_1
X_1783_ wire97/X _1783_/B VGND VGND VDPWR VDPWR _1783_/Y sky130_fd_sc_hd__nand2_1
XFILLER_41_1 VGND VGND VDPWR VDPWR sky130_fd_sc_hd__decap_3
XFILLER_52_144 VGND VGND VDPWR VDPWR sky130_fd_sc_hd__fill_1
XFILLER_71_19 VGND VGND VDPWR VDPWR sky130_fd_sc_hd__decap_3
Xu_sub.u_core.u_regfile.g_word\[3\].g_byte\[0\].u_cg.u_icg clkbuf_leaf_2_clk/X _1540_/Y
+ VGND VGND VDPWR VDPWR u_sub.u_core.u_regfile.g_word\[3\].g_byte\[0\].u_lat/GATE
+ sky130_fd_sc_hd__dlclkp_1
X_2197_ _2210_/CLK hold36/X VGND VGND VDPWR VDPWR _2197_/Q sky130_fd_sc_hd__dfxtp_1
X_1217_ _1212_/A _1212_/B _1216_/Y VGND VGND VDPWR VDPWR _1217_/Y sky130_fd_sc_hd__o21ai_1
X_1148_ _1076_/B _1075_/B _1584_/A _1485_/A VGND VGND VDPWR VDPWR _1148_/Y sky130_fd_sc_hd__a211oi_1
X_1079_ _1213_/A _1757_/A _1213_/B _1757_/B VGND VGND VDPWR VDPWR _1211_/A sky130_fd_sc_hd__o22ai_1
XFILLER_52_188 VGND VGND VDPWR VDPWR sky130_fd_sc_hd__decap_3
Xu_sub.u_core.u_regfile.g_word\[1\].g_byte\[2\].u_cg.u_icg clkload2/A _1530_/Y VGND
+ VGND VDPWR VDPWR u_sub.u_core.u_regfile.g_word\[1\].g_byte\[2\].u_lat/GATE sky130_fd_sc_hd__dlclkp_1
Xhold21 hold21/A VGND VGND VDPWR VDPWR hold21/X sky130_fd_sc_hd__dlygate4sd3_1
Xhold32 hold32/A VGND VGND VDPWR VDPWR hold32/X sky130_fd_sc_hd__dlygate4sd3_1
Xhold43 hold43/A VGND VGND VDPWR VDPWR hold43/X sky130_fd_sc_hd__dlygate4sd3_1
Xhold54 hold54/A VGND VGND VDPWR VDPWR hold54/X sky130_fd_sc_hd__dlygate4sd3_1
Xhold65 hold65/A VGND VGND VDPWR VDPWR hold65/X sky130_fd_sc_hd__dlygate4sd3_1
XFILLER_43_133 VGND VGND VDPWR VDPWR sky130_fd_sc_hd__fill_2
XFILLER_43_188 VGND VGND VDPWR VDPWR sky130_fd_sc_hd__decap_3
XFILLER_45_86 VGND VGND VDPWR VDPWR sky130_fd_sc_hd__decap_3
XANTENNA_7 ui_in[2] VGND VGND VDPWR VDPWR sky130_fd_sc_hd__diode_2
Xu_sub.u_core.u_regfile.g_word\[3\].g_byte\[2\].u_lat max_cap120/X max_cap118/X wire116/X
+ max_cap114/X wire112/X max_cap110/X max_cap108/X max_cap106/X u_sub.u_core.u_regfile.g_word\[3\].g_byte\[2\].u_lat/GATE
+ VGND VDPWR u_sub.u_core.u_regfile.g_word\[3\].g_byte\[2\].u_lat/Q0 u_sub.u_core.u_regfile.g_word\[3\].g_byte\[2\].u_lat/Q1
+ u_sub.u_core.u_regfile.g_word\[3\].g_byte\[2\].u_lat/Q2 u_sub.u_core.u_regfile.g_word\[3\].g_byte\[2\].u_lat/Q3
+ u_sub.u_core.u_regfile.g_word\[3\].g_byte\[2\].u_lat/Q4 u_sub.u_core.u_regfile.g_word\[3\].g_byte\[2\].u_lat/Q5
+ u_sub.u_core.u_regfile.g_word\[3\].g_byte\[2\].u_lat/Q6 u_sub.u_core.u_regfile.g_word\[3\].g_byte\[2\].u_lat/Q7
+ dlxtp8_x1
X_2120_ clkload9/A _2120_/D VGND VGND VDPWR VDPWR uio_out[1] sky130_fd_sc_hd__dfxtp_1
X_1002_ _2214_/D VGND VGND VDPWR VDPWR _1002_/Y sky130_fd_sc_hd__inv_1
X_2051_ clkload6/A hold46/X VGND VGND VDPWR VDPWR _2051_/Q sky130_fd_sc_hd__dfxtp_1
X_1904_ _2137_/Q _2112_/Q VGND VGND VDPWR VDPWR _1908_/C sky130_fd_sc_hd__nand2_1
X_1835_ _1834_/A _1817_/Y _1594_/X VGND VGND VDPWR VDPWR _1835_/X sky130_fd_sc_hd__a21o_1
X_1766_ _1766_/A _1771_/A VGND VGND VDPWR VDPWR _1766_/Y sky130_fd_sc_hd__nand2_1
X_1697_ _2061_/Q _1697_/B VGND VGND VDPWR VDPWR _1698_/C sky130_fd_sc_hd__xnor2_1
XFILLER_40_125 VGND VGND VDPWR VDPWR sky130_fd_sc_hd__decap_3
XFILLER_63_239 VGND VGND VDPWR VDPWR sky130_fd_sc_hd__fill_2
X_1620_ _2137_/Q _1669_/A VGND VGND VDPWR VDPWR _1620_/Y sky130_fd_sc_hd__nor2_1
X_1551_ _1551_/A _1553_/B VGND VGND VDPWR VDPWR _1551_/Y sky130_fd_sc_hd__nor2_1
X_1482_ _1503_/B _1482_/B VGND VGND VDPWR VDPWR _1506_/B sky130_fd_sc_hd__nand2b_1
XFILLER_39_269 VGND VGND VDPWR VDPWR sky130_fd_sc_hd__decap_3
X_2103_ clkload6/A _2103_/D VGND VGND VDPWR VDPWR _2103_/Q sky130_fd_sc_hd__dfxtp_1
XFILLER_54_239 VGND VGND VDPWR VDPWR sky130_fd_sc_hd__fill_2
XTAP_TAPCELL_ROW_64_278 VGND VDPWR sky130_fd_sc_hd__tapvpwrvgnd_1
X_2034_ ui_in[0] hold21/A VGND VGND VDPWR VDPWR _2144_/D sky130_fd_sc_hd__nand2b_1
XFILLER_30_191 VGND VGND VDPWR VDPWR sky130_fd_sc_hd__fill_2
X_1818_ _1834_/A _1817_/Y _1815_/Y VGND VGND VDPWR VDPWR _1818_/Y sky130_fd_sc_hd__o21ai_1
X_1749_ _1749_/A _1756_/C VGND VGND VDPWR VDPWR _1749_/Y sky130_fd_sc_hd__xnor2_1
XFILLER_38_280 VGND VGND VDPWR VDPWR sky130_fd_sc_hd__fill_1
XFILLER_45_206 VGND VGND VDPWR VDPWR sky130_fd_sc_hd__fill_2
XTAP_TAPCELL_ROW_55_234 VGND VDPWR sky130_fd_sc_hd__tapvpwrvgnd_1
XFILLER_53_261 VGND VGND VDPWR VDPWR sky130_fd_sc_hd__fill_1
XTAP_TAPCELL_ROW_78_348 VGND VDPWR sky130_fd_sc_hd__tapvpwrvgnd_1
XTAP_TAPCELL_ROW_69_304 VGND VDPWR sky130_fd_sc_hd__tapvpwrvgnd_1
X_1603_ _2085_/Q _1827_/A VGND VGND VDPWR VDPWR _1603_/Y sky130_fd_sc_hd__nand2b_1
X_1534_ _1539_/A _1534_/B _1534_/C VGND VGND VDPWR VDPWR _1538_/B sky130_fd_sc_hd__or3_1
X_1465_ _2153_/Q _2152_/Q _2156_/Q VGND VGND VDPWR VDPWR _1466_/C sky130_fd_sc_hd__nor3_1
X_2017_ _2217_/Q _1985_/Y _2013_/X _2014_/X _2016_/Y VGND VGND VDPWR VDPWR _2020_/B
+ sky130_fd_sc_hd__o2111ai_1
X_1396_ _1624_/B _1806_/A VGND VGND VDPWR VDPWR _1653_/C sky130_fd_sc_hd__nand2_1
Xhold140 _2116_/Q VGND VGND VDPWR VDPWR hold140/X sky130_fd_sc_hd__dlygate4sd3_1
Xhold151 _2090_/Q VGND VGND VDPWR VDPWR hold151/X sky130_fd_sc_hd__dlygate4sd3_1
XFILLER_37_10 VGND VGND VDPWR VDPWR sky130_fd_sc_hd__decap_3
Xu_sub.u_core.u_regfile.g_nibsel\[3\].g_nib\[2\].u_lo u_sub.u_core.u_regfile.g_word\[3\].g_byte\[0\].u_lat/Q2
+ u_sub.u_core.u_regfile.g_word\[3\].g_byte\[0\].u_lat/Q6 u_sub.u_core.u_regfile.g_word\[3\].g_byte\[1\].u_lat/Q2
+ u_sub.u_core.u_regfile.g_word\[3\].g_byte\[1\].u_lat/Q6 max_cap4/X max_cap3/X VGND
+ VGND VDPWR VDPWR u_sub.u_core.u_regfile.g_nibsel\[3\].g_nib\[2\].u_lo/X tg_mux4_x1
XFILLER_33_209 VGND VGND VDPWR VDPWR sky130_fd_sc_hd__fill_1
XFILLER_37_76 VGND VGND VDPWR VDPWR sky130_fd_sc_hd__decap_3
XFILLER_37_87 VGND VGND VDPWR VDPWR sky130_fd_sc_hd__decap_3
XFILLER_41_242 VGND VGND VDPWR VDPWR sky130_fd_sc_hd__fill_1
X_1250_ _2077_/Q _1250_/B _1250_/C VGND VGND VDPWR VDPWR _1250_/Y sky130_fd_sc_hd__nor3_1
X_1181_ _1242_/A _1181_/B VGND VGND VDPWR VDPWR _1181_/Y sky130_fd_sc_hd__nor2_1
Xclkbuf_3_2__f_clk_regs clkbuf_0_clk_regs/X VGND VGND VDPWR VDPWR clkload6/A sky130_fd_sc_hd__clkbuf_2
XFILLER_71_1 VGND VGND VDPWR VDPWR sky130_fd_sc_hd__decap_3
Xu_sub.u_core.u_regfile.g_nibsel\[1\].g_nib\[1\].u_hi u_sub.u_core.u_regfile.g_word\[1\].g_byte\[2\].u_lat/Q1
+ u_sub.u_core.u_regfile.g_word\[1\].g_byte\[2\].u_lat/Q5 u_sub.u_core.u_regfile.g_word\[1\].g_byte\[3\].u_lat/Q1
+ u_sub.u_core.u_regfile.g_word\[1\].g_byte\[3\].u_lat/Q5 wire83/X max_cap82/X VGND
+ VGND VDPWR VDPWR u_sub.u_core.u_regfile.g_nibsel\[1\].g_nib\[1\].u_hi/X tg_mux4_x1
XFILLER_59_106 VGND VGND VDPWR VDPWR sky130_fd_sc_hd__decap_3
X_1517_ _1515_/Y _1521_/A _1352_/X VGND VGND VDPWR VDPWR _1517_/Y sky130_fd_sc_hd__a21oi_1
X_1448_ _2155_/Q _2153_/Q _2157_/Q VGND VGND VDPWR VDPWR _1448_/Y sky130_fd_sc_hd__nor3_1
XFILLER_15_209 VGND VGND VDPWR VDPWR sky130_fd_sc_hd__decap_3
XFILLER_23_220 VGND VGND VDPWR VDPWR sky130_fd_sc_hd__fill_1
X_1379_ _1379_/A _2128_/Q _2124_/Q VGND VGND VDPWR VDPWR _1379_/Y sky130_fd_sc_hd__nor3b_1
XTAP_TAPCELL_ROW_80_365 VGND VDPWR sky130_fd_sc_hd__tapvpwrvgnd_1
XFILLER_46_301 VGND VGND VDPWR VDPWR sky130_fd_sc_hd__decap_3
XFILLER_58_161 VGND VGND VDPWR VDPWR sky130_fd_sc_hd__decap_3
XFILLER_58_183 VGND VGND VDPWR VDPWR sky130_fd_sc_hd__fill_1
XPHY_EDGE_ROW_45_Left_104 VGND VDPWR sky130_fd_sc_hd__tapvpwrvgnd_1
Xmax_cap8 _1458_/B VGND VGND VDPWR VDPWR _1376_/B sky130_fd_sc_hd__buf_6
XFILLER_14_220 VGND VGND VDPWR VDPWR sky130_fd_sc_hd__decap_3
XPHY_EDGE_ROW_54_Left_113 VGND VDPWR sky130_fd_sc_hd__tapvpwrvgnd_1
XPHY_EDGE_ROW_63_Left_122 VGND VDPWR sky130_fd_sc_hd__tapvpwrvgnd_1
X_1302_ _1302_/A _1302_/B VGND VGND VDPWR VDPWR _1302_/Y sky130_fd_sc_hd__nand2_1
X_1233_ _1215_/C _1231_/Y _1232_/Y VGND VGND VDPWR VDPWR _1259_/A sky130_fd_sc_hd__a21oi_1
XFILLER_64_120 VGND VGND VDPWR VDPWR sky130_fd_sc_hd__fill_2
X_1164_ _1410_/B wire92/X _1164_/C VGND VGND VDPWR VDPWR _1164_/Y sky130_fd_sc_hd__nand3_1
X_1095_ _1095_/A _1095_/B VGND VGND VDPWR VDPWR _1095_/Y sky130_fd_sc_hd__nand2_1
XPHY_EDGE_ROW_72_Left_131 VGND VDPWR sky130_fd_sc_hd__tapvpwrvgnd_1
X_1997_ _1997_/A _1997_/B VGND VGND VDPWR VDPWR _2018_/B sky130_fd_sc_hd__xnor2_1
XFILLER_69_19 VGND VGND VDPWR VDPWR sky130_fd_sc_hd__decap_3
XFILLER_55_142 VGND VGND VDPWR VDPWR sky130_fd_sc_hd__fill_2
XFILLER_55_186 VGND VGND VDPWR VDPWR sky130_fd_sc_hd__decap_3
XFILLER_61_189 VGND VGND VDPWR VDPWR sky130_fd_sc_hd__fill_2
X_1920_ hold53/A _1959_/A VGND VGND VDPWR VDPWR _1920_/Y sky130_fd_sc_hd__nand2b_1
X_1851_ wire97/X _1850_/Y _1840_/Y VGND VGND VDPWR VDPWR _1852_/B sky130_fd_sc_hd__a21oi_1
X_1782_ _1806_/A _1842_/A _1782_/C VGND VGND VDPWR VDPWR _1783_/B sky130_fd_sc_hd__nand3_1
XFILLER_34_1 VGND VGND VDPWR VDPWR sky130_fd_sc_hd__fill_2
Xdelaybuf_22_clk delaybuf_22_clk/A VGND VGND VDPWR VDPWR delaybuf_23_clk/A sky130_fd_sc_hd__clkbuf_2
X_2196_ _2207_/CLK hold29/X VGND VGND VDPWR VDPWR _2196_/Q sky130_fd_sc_hd__dfxtp_1
X_1216_ _1216_/A _1302_/A VGND VGND VDPWR VDPWR _1216_/Y sky130_fd_sc_hd__nand2_1
XFILLER_52_178 VGND VGND VDPWR VDPWR sky130_fd_sc_hd__decap_3
XTAP_TAPCELL_ROW_47_192 VGND VDPWR sky130_fd_sc_hd__tapvpwrvgnd_1
X_1147_ _1498_/C _1139_/D _1046_/C VGND VGND VDPWR VDPWR _1147_/Y sky130_fd_sc_hd__o21bai_1
X_1078_ _1213_/B _1757_/B VGND VGND VDPWR VDPWR _1301_/A sky130_fd_sc_hd__nor2_1
XPHY_EDGE_ROW_37_2_2_Right_56 VGND VDPWR sky130_fd_sc_hd__tapvpwrvgnd_1
Xdelaybuf_13_clk delaybuf_13_clk/A VGND VGND VDPWR VDPWR delaybuf_14_clk/A sky130_fd_sc_hd__clkbuf_2
Xhold22 hold22/A VGND VGND VDPWR VDPWR hold22/X sky130_fd_sc_hd__dlygate4sd3_1
Xhold33 hold33/A VGND VGND VDPWR VDPWR hold33/X sky130_fd_sc_hd__dlygate4sd3_1
Xhold44 hold44/A VGND VGND VDPWR VDPWR hold44/X sky130_fd_sc_hd__dlygate4sd3_1
Xhold55 hold55/A VGND VGND VDPWR VDPWR hold55/X sky130_fd_sc_hd__dlygate4sd3_1
Xhold66 hold66/A VGND VGND VDPWR VDPWR hold66/X sky130_fd_sc_hd__dlygate4sd3_1
XFILLER_45_76 VGND VGND VDPWR VDPWR sky130_fd_sc_hd__decap_3
XANTENNA_8 ui_in[3] VGND VGND VDPWR VDPWR sky130_fd_sc_hd__diode_2
XFILLER_61_97 VGND VGND VDPWR VDPWR sky130_fd_sc_hd__fill_2
X_2050_ clkload6/A hold37/X VGND VGND VDPWR VDPWR _2050_/Q sky130_fd_sc_hd__dfxtp_1
XFILLER_19_197 VGND VGND VDPWR VDPWR sky130_fd_sc_hd__decap_3
X_1001_ _2133_/Q VGND VGND VDPWR VDPWR _1997_/A sky130_fd_sc_hd__inv_1
X_1903_ _1903_/A _1903_/B VGND VGND VDPWR VDPWR _2114_/D sky130_fd_sc_hd__nor2_1
X_1834_ _1834_/A _1834_/B VGND VGND VDPWR VDPWR _1834_/Y sky130_fd_sc_hd__nor2_1
X_1765_ _1770_/B _1764_/Y _1763_/Y VGND VGND VDPWR VDPWR _2082_/D sky130_fd_sc_hd__a21oi_1
X_1696_ _1690_/Y _2070_/Q _2071_/Q VGND VGND VDPWR VDPWR _1697_/B sky130_fd_sc_hd__nand3b_1
X_2179_ _2194_/CLK hold44/X VGND VGND VDPWR VDPWR _2179_/Q sky130_fd_sc_hd__dfxtp_1
XFILLER_48_248 VGND VGND VDPWR VDPWR sky130_fd_sc_hd__decap_3
XFILLER_63_229 VGND VGND VDPWR VDPWR sky130_fd_sc_hd__fill_1
XFILLER_71_273 VGND VGND VDPWR VDPWR sky130_fd_sc_hd__fill_1
XFILLER_68_7 VGND VGND VDPWR VDPWR sky130_fd_sc_hd__decap_3
X_1550_ _1550_/A _1553_/B VGND VGND VDPWR VDPWR _1550_/Y sky130_fd_sc_hd__nor2_1
X_1481_ _1950_/A _1476_/B _1480_/Y VGND VGND VDPWR VDPWR _1503_/B sky130_fd_sc_hd__o21ai_1
XFILLER_39_237 VGND VGND VDPWR VDPWR sky130_fd_sc_hd__fill_1
XFILLER_39_259 VGND VGND VDPWR VDPWR sky130_fd_sc_hd__fill_2
XFILLER_47_270 VGND VGND VDPWR VDPWR sky130_fd_sc_hd__fill_2
X_2102_ clkload4/A _2102_/D VGND VGND VDPWR VDPWR _2102_/Q sky130_fd_sc_hd__dfxtp_1
X_2033_ _2037_/A _2033_/B _1442_/B _2039_/B VGND VGND VDPWR VDPWR _2143_/D sky130_fd_sc_hd__nor4bb_1
XFILLER_62_273 VGND VGND VDPWR VDPWR sky130_fd_sc_hd__fill_2
XTAP_TAPCELL_ROW_64_279 VGND VDPWR sky130_fd_sc_hd__tapvpwrvgnd_1
X_1817_ _1827_/A _1764_/Y _1816_/Y VGND VGND VDPWR VDPWR _1817_/Y sky130_fd_sc_hd__a21oi_1
X_1748_ _1748_/A _1748_/B VGND VGND VDPWR VDPWR _2077_/D sky130_fd_sc_hd__nor2_1
X_1679_ _1679_/A _1679_/B VGND VGND VDPWR VDPWR _2055_/D sky130_fd_sc_hd__nor2_1
XFILLER_53_251 VGND VGND VDPWR VDPWR sky130_fd_sc_hd__decap_3
XTAP_TAPCELL_ROW_55_235 VGND VDPWR sky130_fd_sc_hd__tapvpwrvgnd_1
Xu_sub.u_core.u_regfile.g_ir\[2\].u_lat _2093_/Q _2094_/Q wire116/X _2096_/Q wire112/X
+ max_cap110/X _2099_/Q max_cap107/X u_sub.u_core.u_regfile.g_ir\[2\].u_lat/GATE VGND
+ VDPWR _1153_/C _1151_/B _1350_/A _1316_/B _1166_/A _1121_/D _1278_/A _1348_/A dlxtp8_x1
XFILLER_42_66 VGND VGND VDPWR VDPWR sky130_fd_sc_hd__fill_2
XPHY_EDGE_ROW_21_2_2_Right_40 VGND VDPWR sky130_fd_sc_hd__tapvpwrvgnd_1
XFILLER_67_30 VGND VGND VDPWR VDPWR sky130_fd_sc_hd__decap_3
XFILLER_67_41 VGND VGND VDPWR VDPWR sky130_fd_sc_hd__fill_1
XFILLER_67_85 VGND VGND VDPWR VDPWR sky130_fd_sc_hd__fill_2
XTAP_TAPCELL_ROW_78_349 VGND VDPWR sky130_fd_sc_hd__tapvpwrvgnd_1
XFILLER_44_251 VGND VGND VDPWR VDPWR sky130_fd_sc_hd__fill_2
XFILLER_44_262 VGND VGND VDPWR VDPWR sky130_fd_sc_hd__decap_3
XFILLER_44_273 VGND VGND VDPWR VDPWR sky130_fd_sc_hd__decap_3
XFILLER_44_284 VGND VGND VDPWR VDPWR sky130_fd_sc_hd__decap_3
Xclkbuf_3_1__f_clk_regs clkbuf_0_clk_regs/X VGND VGND VDPWR VDPWR clkload5/A sky130_fd_sc_hd__clkbuf_2
Xu_sub.u_core.u_regfile.g_nibsel\[4\].g_nib\[0\].u_lo u_sub.u_core.u_regfile.g_word\[4\].g_byte\[0\].u_lat/Q0
+ u_sub.u_core.u_regfile.g_word\[4\].g_byte\[0\].u_lat/Q4 u_sub.u_core.u_regfile.g_word\[4\].g_byte\[1\].u_lat/Q0
+ u_sub.u_core.u_regfile.g_word\[4\].g_byte\[1\].u_lat/Q4 max_cap5/X max_cap3/X VGND
+ VGND VDPWR VDPWR u_sub.u_core.u_regfile.g_nibsel\[4\].g_nib\[0\].u_lo/X tg_mux4_x1
X_1602_ _1827_/A _1825_/C _1601_/Y VGND VGND VDPWR VDPWR _1819_/B sky130_fd_sc_hd__o21ai_1
XTAP_TAPCELL_ROW_69_305 VGND VDPWR sky130_fd_sc_hd__tapvpwrvgnd_1
Xu_sub.u_core.u_regfile.g_port\[1\].u_za u_sub.u_core.u_regfile.g_port\[1\].u_a/X
+ _1154_/Y VGND VGND VDPWR VDPWR _1608_/A1 sky130_fd_sc_hd__and2_1
X_1533_ _1534_/B _1534_/C VGND VGND VDPWR VDPWR _1539_/B sky130_fd_sc_hd__nor2_1
X_1464_ _2158_/Q _2154_/Q VGND VGND VDPWR VDPWR _1466_/B sky130_fd_sc_hd__nor2_1
X_1395_ _1393_/Y _1394_/Y wire7/X VGND VGND VDPWR VDPWR _1395_/Y sky130_fd_sc_hd__a21boi_1
X_2016_ _2217_/Q _1985_/Y _2015_/Y VGND VGND VDPWR VDPWR _2016_/Y sky130_fd_sc_hd__a21oi_1
XFILLER_50_276 VGND VGND VDPWR VDPWR sky130_fd_sc_hd__decap_3
XTAP_TAPCELL_ROW_60_260 VGND VDPWR sky130_fd_sc_hd__tapvpwrvgnd_1
Xhold141 _2074_/Q VGND VGND VDPWR VDPWR _1736_/A sky130_fd_sc_hd__dlygate4sd3_1
Xhold152 _2196_/Q VGND VGND VDPWR VDPWR hold152/X sky130_fd_sc_hd__dlygate4sd3_1
XFILLER_18_207 VGND VGND VDPWR VDPWR sky130_fd_sc_hd__fill_1
XFILLER_18_218 VGND VGND VDPWR VDPWR sky130_fd_sc_hd__fill_1
XFILLER_41_287 VGND VGND VDPWR VDPWR sky130_fd_sc_hd__fill_1
XFILLER_5_188 VGND VGND VDPWR VDPWR sky130_fd_sc_hd__decap_3
XTAP_TAPCELL_ROW_74_330 VGND VDPWR sky130_fd_sc_hd__tapvpwrvgnd_1
X_1180_ _1174_/A _1121_/B _1179_/X VGND VGND VDPWR VDPWR _1181_/B sky130_fd_sc_hd__o21ai_1
X_1516_ _1516_/A _1562_/B VGND VGND VDPWR VDPWR _1521_/A sky130_fd_sc_hd__nor2_1
X_1447_ _1555_/B VGND VGND VDPWR VDPWR _1447_/Y sky130_fd_sc_hd__inv_1
X_1378_ _2127_/Q _2125_/Q _1376_/Y _2126_/Q VGND VGND VDPWR VDPWR _1379_/A sky130_fd_sc_hd__o22ai_1
XTAP_TAPCELL_ROW_80_366 VGND VDPWR sky130_fd_sc_hd__tapvpwrvgnd_1
XFILLER_64_86 VGND VGND VDPWR VDPWR sky130_fd_sc_hd__fill_2
Xclkbuf_leaf_1_clk delaybuf_16_clk/X VGND VGND VDPWR VDPWR clkload1/A sky130_fd_sc_hd__clkbuf_2
X_1301_ _1301_/A _1301_/B VGND VGND VDPWR VDPWR _1302_/B sky130_fd_sc_hd__nand2_1
X_1232_ _1608_/A1 _1647_/B _1098_/Y _2164_/Q VGND VGND VDPWR VDPWR _1232_/Y sky130_fd_sc_hd__o22ai_1
XFILLER_64_165 VGND VGND VDPWR VDPWR sky130_fd_sc_hd__fill_2
X_1163_ _1163_/A VGND VGND VDPWR VDPWR _1164_/C sky130_fd_sc_hd__inv_1
X_1094_ hold56/A _1021_/Y _1744_/B hold53/A _1311_/B1 hold58/A VGND VGND VDPWR VDPWR
+ _1095_/B sky130_fd_sc_hd__a222oi_1
X_1996_ _1997_/A _1997_/B VGND VGND VDPWR VDPWR _2004_/C sky130_fd_sc_hd__nor2_1
XFILLER_55_121 VGND VGND VDPWR VDPWR sky130_fd_sc_hd__decap_3
XFILLER_11_235 VGND VGND VDPWR VDPWR sky130_fd_sc_hd__fill_1
XFILLER_43_338 VGND VGND VDPWR VDPWR sky130_fd_sc_hd__decap_3
XFILLER_50_66 VGND VGND VDPWR VDPWR sky130_fd_sc_hd__fill_2
Xclkload0 clkload0/A VGND VGND VDPWR VDPWR clkload0/Y sky130_fd_sc_hd__inv_2
Xwire137 wire137/A VGND VGND VDPWR VDPWR _1188_/A sky130_fd_sc_hd__clkbuf_4
XFILLER_46_121 VGND VGND VDPWR VDPWR sky130_fd_sc_hd__decap_3
XFILLER_46_132 VGND VGND VDPWR VDPWR sky130_fd_sc_hd__decap_3
XFILLER_46_154 VGND VGND VDPWR VDPWR sky130_fd_sc_hd__decap_3
XFILLER_46_176 VGND VGND VDPWR VDPWR sky130_fd_sc_hd__decap_3
XFILLER_46_198 VGND VGND VDPWR VDPWR sky130_fd_sc_hd__fill_1
XFILLER_61_124 VGND VGND VDPWR VDPWR sky130_fd_sc_hd__decap_3
XPHY_EDGE_ROW_18_2_2_Right_37 VGND VDPWR sky130_fd_sc_hd__tapvpwrvgnd_1
X_1850_ _1806_/A _1845_/Y _1849_/Y VGND VGND VDPWR VDPWR _1850_/Y sky130_fd_sc_hd__a21oi_1
X_1781_ _2136_/Q _2132_/Q _1841_/S VGND VGND VDPWR VDPWR _1782_/C sky130_fd_sc_hd__mux2_1
XFILLER_37_143 VGND VGND VDPWR VDPWR sky130_fd_sc_hd__decap_3
X_2195_ _2207_/CLK hold25/X VGND VGND VDPWR VDPWR _2195_/Q sky130_fd_sc_hd__dfxtp_1
X_1215_ _1215_/A _1593_/A _1215_/C _1215_/D VGND VGND VDPWR VDPWR _1302_/A sky130_fd_sc_hd__nand4_1
X_1146_ _1348_/A _1348_/B _1112_/Y _1431_/A VGND VGND VDPWR VDPWR _1146_/X sky130_fd_sc_hd__a31o_1
XFILLER_37_198 VGND VGND VDPWR VDPWR sky130_fd_sc_hd__decap_3
XTAP_TAPCELL_ROW_47_193 VGND VDPWR sky130_fd_sc_hd__tapvpwrvgnd_1
X_1077_ _1057_/B _1376_/B _1053_/B _1599_/B VGND VGND VDPWR VDPWR _1757_/B sky130_fd_sc_hd__a31oi_1
X_1979_ _2141_/Q _2142_/Q _2027_/A VGND VGND VDPWR VDPWR _2031_/B sky130_fd_sc_hd__nand3_1
Xhold23 hold23/A VGND VGND VDPWR VDPWR hold23/X sky130_fd_sc_hd__dlygate4sd3_1
Xhold34 hold34/A VGND VGND VDPWR VDPWR hold34/X sky130_fd_sc_hd__dlygate4sd3_1
Xhold45 hold45/A VGND VGND VDPWR VDPWR hold45/X sky130_fd_sc_hd__dlygate4sd3_1
Xhold56 hold56/A VGND VGND VDPWR VDPWR hold56/X sky130_fd_sc_hd__dlygate4sd3_1
XFILLER_43_168 VGND VGND VDPWR VDPWR sky130_fd_sc_hd__fill_2
Xhold67 hold67/A VGND VGND VDPWR VDPWR hold67/X sky130_fd_sc_hd__dlygate4sd3_1
XFILLER_43_179 VGND VGND VDPWR VDPWR sky130_fd_sc_hd__decap_3
XANTENNA_9 uio_in[6] VGND VGND VDPWR VDPWR sky130_fd_sc_hd__diode_2
XFILLER_3_220 VGND VGND VDPWR VDPWR sky130_fd_sc_hd__fill_1
Xdelaybuf_6_clk delaybuf_6_clk/A VGND VGND VDPWR VDPWR delaybuf_7_clk/A sky130_fd_sc_hd__clkbuf_2
XFILLER_59_290 VGND VGND VDPWR VDPWR sky130_fd_sc_hd__fill_2
XFILLER_34_135 VGND VGND VDPWR VDPWR sky130_fd_sc_hd__fill_1
X_1902_ _2214_/D _1894_/X _2044_/A VGND VGND VDPWR VDPWR _1903_/B sky130_fd_sc_hd__o21ai_1
X_1833_ _1833_/A _1854_/B VGND VGND VDPWR VDPWR _1839_/B sky130_fd_sc_hd__nand2_1
X_1764_ _1764_/A1 _1598_/Y _1599_/Y VGND VGND VDPWR VDPWR _1764_/Y sky130_fd_sc_hd__a21boi_1
XFILLER_57_216 VGND VGND VDPWR VDPWR sky130_fd_sc_hd__decap_3
X_1695_ _2067_/Q _2059_/Q _1729_/A VGND VGND VDPWR VDPWR _2060_/D sky130_fd_sc_hd__and3_1
X_2178_ _2178_/CLK _2178_/D _2039_/B VGND VGND VDPWR VDPWR hold66/A sky130_fd_sc_hd__dfrtp_1
X_1129_ _1129_/A _1138_/B VGND VGND VDPWR VDPWR _1169_/C sky130_fd_sc_hd__nor2_1
XFILLER_40_149 VGND VGND VDPWR VDPWR sky130_fd_sc_hd__decap_3
XFILLER_48_205 VGND VGND VDPWR VDPWR sky130_fd_sc_hd__fill_1
XFILLER_48_227 VGND VGND VDPWR VDPWR sky130_fd_sc_hd__decap_3
Xclkbuf_3_0__f_clk_regs clkbuf_0_clk_regs/X VGND VGND VDPWR VDPWR clkload4/A sky130_fd_sc_hd__clkbuf_2
XFILLER_71_230 VGND VGND VDPWR VDPWR sky130_fd_sc_hd__fill_1
Xu_sub.u_core.u_regfile.g_port\[3\].u_a u_sub.u_core.u_regfile.g_port\[3\].u_b/A0
+ u_sub.u_core.u_regfile.g_port\[3\].u_b/A1 u_sub.u_core.u_regfile.g_port\[3\].u_b/A2
+ u_sub.u_core.u_regfile.g_port\[3\].u_b/A3 wire93/X _1430_/X VGND VGND VDPWR VDPWR
+ u_sub.u_core.u_regfile.g_port\[3\].u_a/X tg_mux4_x1
X_1480_ _2043_/B _1463_/A _1479_/Y VGND VGND VDPWR VDPWR _1480_/Y sky130_fd_sc_hd__a21oi_1
XFILLER_47_282 VGND VGND VDPWR VDPWR sky130_fd_sc_hd__fill_1
XFILLER_54_208 VGND VGND VDPWR VDPWR sky130_fd_sc_hd__decap_3
X_2101_ clkload8/A _2101_/D VGND VGND VDPWR VDPWR _2101_/Q sky130_fd_sc_hd__dfxtp_1
X_2032_ _2032_/A _2032_/B VGND VGND VDPWR VDPWR _2142_/D sky130_fd_sc_hd__nor2_1
X_1816_ _2082_/Q _1827_/A VGND VGND VDPWR VDPWR _1816_/Y sky130_fd_sc_hd__nor2_1
X_1747_ _1747_/A _1747_/B VGND VGND VDPWR VDPWR _1748_/B sky130_fd_sc_hd__nor2_1
X_1678_ wire70/X _1687_/B VGND VGND VDPWR VDPWR _1679_/B sky130_fd_sc_hd__nor2_1
XTAP_TAPCELL_ROW_55_236 VGND VDPWR sky130_fd_sc_hd__tapvpwrvgnd_1
XFILLER_44_230 VGND VGND VDPWR VDPWR sky130_fd_sc_hd__decap_3
XPHY_EDGE_ROW_42_Right_61 VGND VDPWR sky130_fd_sc_hd__tapvpwrvgnd_1
XPHY_EDGE_ROW_51_Right_70 VGND VDPWR sky130_fd_sc_hd__tapvpwrvgnd_1
X_1601_ _2084_/Q _1827_/A VGND VGND VDPWR VDPWR _1601_/Y sky130_fd_sc_hd__nand2_1
X_1532_ _1532_/A _1553_/A VGND VGND VDPWR VDPWR _1532_/Y sky130_fd_sc_hd__nor2_1
XTAP_TAPCELL_ROW_69_306 VGND VDPWR sky130_fd_sc_hd__tapvpwrvgnd_1
Xu_sub.u_core.u_regfile.g_port\[1\].u_zb u_sub.u_core.u_regfile.g_port\[1\].u_b/X
+ _1146_/X VGND VGND VDPWR VDPWR _1777_/A1 sky130_fd_sc_hd__and2_1
X_1463_ _1463_/A _1478_/B VGND VGND VDPWR VDPWR _1504_/B sky130_fd_sc_hd__nor2_1
X_1394_ _2102_/Q _2068_/Q _1389_/Y VGND VGND VDPWR VDPWR _1394_/Y sky130_fd_sc_hd__o21ai_1
XTAP_TAPCELL_ROW_52_217 VGND VDPWR sky130_fd_sc_hd__tapvpwrvgnd_1
X_2015_ _2129_/Q _2216_/Q VGND VGND VDPWR VDPWR _2015_/Y sky130_fd_sc_hd__xnor2_1
XTAP_TAPCELL_ROW_60_261 VGND VDPWR sky130_fd_sc_hd__tapvpwrvgnd_1
Xhold142 _2144_/Q VGND VGND VDPWR VDPWR hold142/X sky130_fd_sc_hd__dlygate4sd3_1
Xhold153 _2069_/Q VGND VGND VDPWR VDPWR _1724_/A sky130_fd_sc_hd__dlygate4sd3_1
XFILLER_58_344 VGND VGND VDPWR VDPWR sky130_fd_sc_hd__fill_1
XFILLER_41_277 VGND VGND VDPWR VDPWR sky130_fd_sc_hd__decap_3
XFILLER_17_230 VGND VGND VDPWR VDPWR sky130_fd_sc_hd__fill_1
XPHY_EDGE_ROW_20_2_2_Left_9 VGND VDPWR sky130_fd_sc_hd__tapvpwrvgnd_1
XTAP_TAPCELL_ROW_74_331 VGND VDPWR sky130_fd_sc_hd__tapvpwrvgnd_1
Xu_sub.u_core.u_regfile.g_nibsel\[1\].g_nib\[1\].u_lo u_sub.u_core.u_regfile.g_word\[1\].g_byte\[0\].u_lat/Q1
+ u_sub.u_core.u_regfile.g_word\[1\].g_byte\[0\].u_lat/Q5 u_sub.u_core.u_regfile.g_word\[1\].g_byte\[1\].u_lat/Q1
+ u_sub.u_core.u_regfile.g_word\[1\].g_byte\[1\].u_lat/Q5 wire83/X max_cap82/X VGND
+ VGND VDPWR VDPWR u_sub.u_core.u_regfile.g_nibsel\[1\].g_nib\[1\].u_lo/X tg_mux4_x1
XFILLER_57_1 VGND VGND VDPWR VDPWR sky130_fd_sc_hd__fill_2
X_1515_ _1827_/A _1515_/B VGND VGND VDPWR VDPWR _1515_/Y sky130_fd_sc_hd__xnor2_1
XFILLER_67_196 VGND VGND VDPWR VDPWR sky130_fd_sc_hd__fill_1
X_1446_ _2038_/A _2037_/A _1780_/A _1669_/A VGND VGND VDPWR VDPWR _1555_/B sky130_fd_sc_hd__or4_1
X_1377_ _1360_/B _2126_/Q _1376_/Y VGND VGND VDPWR VDPWR _1377_/Y sky130_fd_sc_hd__o21ai_1
XFILLER_23_200 VGND VGND VDPWR VDPWR sky130_fd_sc_hd__fill_2
XFILLER_23_211 VGND VGND VDPWR VDPWR sky130_fd_sc_hd__decap_3
XFILLER_23_222 VGND VGND VDPWR VDPWR sky130_fd_sc_hd__fill_1
XFILLER_70_339 VGND VGND VDPWR VDPWR sky130_fd_sc_hd__fill_1
XFILLER_48_66 VGND VGND VDPWR VDPWR sky130_fd_sc_hd__fill_2
XFILLER_58_141 VGND VGND VDPWR VDPWR sky130_fd_sc_hd__decap_3
XFILLER_14_200 VGND VGND VDPWR VDPWR sky130_fd_sc_hd__decap_3
XFILLER_14_211 VGND VGND VDPWR VDPWR sky130_fd_sc_hd__fill_2
XFILLER_48_99 VGND VGND VDPWR VDPWR sky130_fd_sc_hd__fill_2
XTAP_TAPCELL_ROW_71_312 VGND VDPWR sky130_fd_sc_hd__tapvpwrvgnd_1
XFILLER_14_233 VGND VGND VDPWR VDPWR sky130_fd_sc_hd__decap_3
XFILLER_49_174 VGND VGND VDPWR VDPWR sky130_fd_sc_hd__decap_3
X_1300_ _1300_/A _1300_/B VGND VGND VDPWR VDPWR _1301_/B sky130_fd_sc_hd__nand2_1
X_1231_ _1608_/A1 _1086_/X _1087_/Y _1230_/Y VGND VGND VDPWR VDPWR _1231_/Y sky130_fd_sc_hd__a22oi_1
X_1162_ _2092_/Q _1053_/B _1169_/C VGND VGND VDPWR VDPWR _1163_/A sky130_fd_sc_hd__a21oi_1
XFILLER_64_144 VGND VGND VDPWR VDPWR sky130_fd_sc_hd__decap_3
X_1093_ _2076_/Q _1841_/S VGND VGND VDPWR VDPWR _1746_/A sky130_fd_sc_hd__nand2_1
X_1995_ _2021_/A1 _2013_/B _1994_/Y VGND VGND VDPWR VDPWR _2132_/D sky130_fd_sc_hd__a21oi_1
X_1429_ _2052_/Q _1723_/B _1723_/C _1429_/D VGND VGND VDPWR VDPWR _1429_/X sky130_fd_sc_hd__and4_1
XFILLER_55_100 VGND VGND VDPWR VDPWR sky130_fd_sc_hd__fill_2
XFILLER_55_133 VGND VGND VDPWR VDPWR sky130_fd_sc_hd__decap_3
XFILLER_55_166 VGND VGND VDPWR VDPWR sky130_fd_sc_hd__fill_1
XFILLER_55_177 VGND VGND VDPWR VDPWR sky130_fd_sc_hd__fill_1
Xu_sub.u_core.u_regfile.g_word\[2\].g_byte\[1\].u_lat max_cap120/X max_cap118/X wire116/X
+ max_cap114/X wire112/X max_cap110/X max_cap108/X max_cap106/X u_sub.u_core.u_regfile.g_word\[2\].g_byte\[1\].u_lat/GATE
+ VGND VDPWR u_sub.u_core.u_regfile.g_word\[2\].g_byte\[1\].u_lat/Q0 u_sub.u_core.u_regfile.g_word\[2\].g_byte\[1\].u_lat/Q1
+ u_sub.u_core.u_regfile.g_word\[2\].g_byte\[1\].u_lat/Q2 u_sub.u_core.u_regfile.g_word\[2\].g_byte\[1\].u_lat/Q3
+ u_sub.u_core.u_regfile.g_word\[2\].g_byte\[1\].u_lat/Q4 u_sub.u_core.u_regfile.g_word\[2\].g_byte\[1\].u_lat/Q5
+ u_sub.u_core.u_regfile.g_word\[2\].g_byte\[1\].u_lat/Q6 u_sub.u_core.u_regfile.g_word\[2\].g_byte\[1\].u_lat/Q7
+ dlxtp8_x1
Xclkload1 clkload1/A VGND VGND VDPWR VDPWR clkload1/Y sky130_fd_sc_hd__clkinv_16
Xwire116 wire116/A VGND VGND VDPWR VDPWR wire116/X sky130_fd_sc_hd__buf_6
Xwire105 hold22/X VGND VGND VDPWR VDPWR wire105/X sky130_fd_sc_hd__buf_6
XFILLER_61_169 VGND VGND VDPWR VDPWR sky130_fd_sc_hd__fill_1
X_1780_ _1780_/A _1881_/B VGND VGND VDPWR VDPWR _1842_/A sky130_fd_sc_hd__nor2_1
XFILLER_41_4 VGND VGND VDPWR VDPWR sky130_fd_sc_hd__decap_3
X_2194_ _2194_/CLK _2194_/D VGND VGND VDPWR VDPWR hold50/A sky130_fd_sc_hd__dfxtp_1
X_1214_ _1301_/A _1214_/B VGND VGND VDPWR VDPWR _1216_/A sky130_fd_sc_hd__nand2_1
X_1145_ _1348_/B _1348_/C _1115_/B _1112_/Y VGND VGND VDPWR VDPWR _1431_/A sky130_fd_sc_hd__a22o_1
XTAP_TAPCELL_ROW_47_194 VGND VDPWR sky130_fd_sc_hd__tapvpwrvgnd_1
X_1076_ _1132_/A _1076_/B _1076_/C VGND VGND VDPWR VDPWR _1599_/B sky130_fd_sc_hd__and3_1
X_1978_ _2138_/Q _2139_/Q _2140_/Q VGND VGND VDPWR VDPWR _2027_/A sky130_fd_sc_hd__and3_1
Xhold24 hold24/A VGND VGND VDPWR VDPWR hold24/X sky130_fd_sc_hd__dlygate4sd3_1
Xhold35 hold35/A VGND VGND VDPWR VDPWR hold35/X sky130_fd_sc_hd__dlygate4sd3_1
Xhold46 hold46/A VGND VGND VDPWR VDPWR hold46/X sky130_fd_sc_hd__dlygate4sd3_1
Xhold57 hold57/A VGND VGND VDPWR VDPWR hold57/X sky130_fd_sc_hd__dlygate4sd3_1
XFILLER_28_188 VGND VGND VDPWR VDPWR sky130_fd_sc_hd__decap_3
XFILLER_45_89 VGND VGND VDPWR VDPWR sky130_fd_sc_hd__fill_2
XFILLER_51_191 VGND VGND VDPWR VDPWR sky130_fd_sc_hd__fill_1
XFILLER_3_232 VGND VGND VDPWR VDPWR sky130_fd_sc_hd__decap_3
XFILLER_19_188 VGND VGND VDPWR VDPWR sky130_fd_sc_hd__decap_3
XFILLER_66_228 VGND VGND VDPWR VDPWR sky130_fd_sc_hd__fill_2
XFILLER_42_191 VGND VGND VDPWR VDPWR sky130_fd_sc_hd__decap_3
X_1901_ _2114_/Q _1901_/B VGND VGND VDPWR VDPWR _1903_/A sky130_fd_sc_hd__nor2_1
X_1832_ _1813_/X _1831_/Y _1352_/X VGND VGND VDPWR VDPWR _2094_/D sky130_fd_sc_hd__a21oi_1
X_1763_ _2082_/Q _1770_/B VGND VGND VDPWR VDPWR _1763_/Y sky130_fd_sc_hd__nor2_1
X_1694_ _1694_/A _1729_/A VGND VGND VDPWR VDPWR _2059_/D sky130_fd_sc_hd__nor2b_1
X_2177_ _2178_/CLK _2177_/D _2039_/B VGND VGND VDPWR VDPWR hold55/A sky130_fd_sc_hd__dfrtp_1
X_1128_ _1128_/A _1128_/B _1128_/C _1220_/A VGND VGND VDPWR VDPWR _1138_/B sky130_fd_sc_hd__nand4_1
X_1059_ _1056_/Y _1058_/Y _1132_/A VGND VGND VDPWR VDPWR _1060_/C sky130_fd_sc_hd__o21ai_1
XFILLER_40_128 VGND VGND VDPWR VDPWR sky130_fd_sc_hd__fill_1
XFILLER_56_66 VGND VGND VDPWR VDPWR sky130_fd_sc_hd__fill_2
XFILLER_71_220 VGND VGND VDPWR VDPWR sky130_fd_sc_hd__decap_3
Xu_sub.u_core.u_regfile.g_port\[3\].u_b u_sub.u_core.u_regfile.g_port\[3\].u_b/A0
+ u_sub.u_core.u_regfile.g_port\[3\].u_b/A1 u_sub.u_core.u_regfile.g_port\[3\].u_b/A2
+ u_sub.u_core.u_regfile.g_port\[3\].u_b/A3 _1349_/Y _1431_/Y VGND VGND VDPWR VDPWR
+ u_sub.u_core.u_regfile.g_port\[3\].u_b/X tg_mux4_x1
XFILLER_39_239 VGND VGND VDPWR VDPWR sky130_fd_sc_hd__decap_3
X_2100_ _2100_/CLK _2100_/D VGND VGND VDPWR VDPWR _2100_/Q sky130_fd_sc_hd__dfxtp_1
X_2031_ _2039_/B _2031_/B VGND VGND VDPWR VDPWR _2032_/B sky130_fd_sc_hd__nand2_1
X_1815_ _1834_/A _1815_/B VGND VGND VDPWR VDPWR _1815_/Y sky130_fd_sc_hd__nand2_1
Xu_sub.u_core.u_regfile.g_nibsel\[2\].g_nib\[3\].u_m2 u_sub.u_core.u_regfile.g_nibsel\[2\].g_nib\[3\].u_lo/X
+ u_sub.u_core.u_regfile.g_nibsel\[2\].g_nib\[3\].u_hi/X max_cap1/X VGND VGND VDPWR
+ VDPWR u_sub.u_core.u_regfile.g_port\[3\].u_b/A1 sky130_fd_sc_hd__mux2_1
X_1746_ _1746_/A _1750_/B VGND VGND VDPWR VDPWR _1747_/B sky130_fd_sc_hd__nor2_1
X_1677_ _2055_/Q wire71/X _2044_/A VGND VGND VDPWR VDPWR _1679_/A sky130_fd_sc_hd__o21ai_1
XFILLER_38_250 VGND VGND VDPWR VDPWR sky130_fd_sc_hd__decap_3
X_2229_ _2230_/A VGND VGND VDPWR VDPWR uio_oe[2] sky130_fd_sc_hd__buf_2
XFILLER_53_220 VGND VGND VDPWR VDPWR sky130_fd_sc_hd__decap_3
XFILLER_53_275 VGND VGND VDPWR VDPWR sky130_fd_sc_hd__fill_1
XFILLER_67_10 VGND VGND VDPWR VDPWR sky130_fd_sc_hd__decap_3
XFILLER_44_242 VGND VGND VDPWR VDPWR sky130_fd_sc_hd__decap_3
X_1600_ _1600_/A1 _1598_/Y _1599_/Y VGND VGND VDPWR VDPWR _1825_/C sky130_fd_sc_hd__a21boi_1
X_1531_ _1531_/A _1531_/B VGND VGND VDPWR VDPWR _1553_/A sky130_fd_sc_hd__nand2_1
X_1462_ _2154_/Q _1462_/B _1462_/C VGND VGND VDPWR VDPWR _1478_/B sky130_fd_sc_hd__nor3_1
X_1393_ _2107_/Q _2069_/Q _2052_/Q _1723_/C VGND VGND VDPWR VDPWR _1393_/Y sky130_fd_sc_hd__o211ai_1
XTAP_TAPCELL_ROW_52_218 VGND VDPWR sky130_fd_sc_hd__tapvpwrvgnd_1
X_2014_ _2218_/Q _2014_/B VGND VGND VDPWR VDPWR _2014_/X sky130_fd_sc_hd__xor2_1
Xhold143 hold67/A VGND VGND VDPWR VDPWR _1644_/A sky130_fd_sc_hd__dlygate4sd3_1
X_1729_ _1729_/A _1729_/B VGND VGND VDPWR VDPWR _2071_/D sky130_fd_sc_hd__and2_1
XFILLER_37_13 VGND VGND VDPWR VDPWR sky130_fd_sc_hd__decap_3
XFILLER_37_35 VGND VGND VDPWR VDPWR sky130_fd_sc_hd__decap_3
XFILLER_37_68 VGND VGND VDPWR VDPWR sky130_fd_sc_hd__fill_2
XFILLER_37_79 VGND VGND VDPWR VDPWR sky130_fd_sc_hd__fill_1
Xu_sub.u_core.u_regfile.g_port\[2\].u_a u_sub.u_core.u_regfile.g_port\[2\].u_b/A0
+ u_sub.u_core.u_regfile.g_port\[2\].u_b/A1 u_sub.u_core.u_regfile.g_port\[2\].u_b/A2
+ u_sub.u_core.u_regfile.g_port\[2\].u_b/A3 wire93/X _1430_/X VGND VGND VDPWR VDPWR
+ u_sub.u_core.u_regfile.g_port\[2\].u_a/X tg_mux4_x1
XFILLER_41_201 VGND VGND VDPWR VDPWR sky130_fd_sc_hd__fill_2
XFILLER_64_337 VGND VGND VDPWR VDPWR sky130_fd_sc_hd__decap_3
XFILLER_71_4 VGND VGND VDPWR VDPWR sky130_fd_sc_hd__decap_3
XFILLER_59_109 VGND VGND VDPWR VDPWR sky130_fd_sc_hd__decap_3
X_1514_ _1520_/A _1744_/B VGND VGND VDPWR VDPWR _1515_/B sky130_fd_sc_hd__nor2_1
X_1445_ _2151_/Q _2181_/Q _1443_/Y VGND VGND VDPWR VDPWR _1445_/Y sky130_fd_sc_hd__o21ai_1
X_1376_ _2151_/Q _1376_/B _2125_/Q VGND VGND VDPWR VDPWR _1376_/Y sky130_fd_sc_hd__nor3_1
XFILLER_23_234 VGND VGND VDPWR VDPWR sky130_fd_sc_hd__fill_2
XTAP_TAPCELL_ROW_80_357 VGND VDPWR sky130_fd_sc_hd__tapvpwrvgnd_1
XFILLER_46_304 VGND VGND VDPWR VDPWR sky130_fd_sc_hd__decap_3
XFILLER_58_120 VGND VGND VDPWR VDPWR sky130_fd_sc_hd__fill_2
XFILLER_58_164 VGND VGND VDPWR VDPWR sky130_fd_sc_hd__decap_3
XPHY_EDGE_ROW_70_Right_89 VGND VDPWR sky130_fd_sc_hd__tapvpwrvgnd_1
XFILLER_14_223 VGND VGND VDPWR VDPWR sky130_fd_sc_hd__fill_1
XFILLER_64_66 VGND VGND VDPWR VDPWR sky130_fd_sc_hd__fill_2
XPHY_EDGE_ROW_33_2_2_Right_52 VGND VDPWR sky130_fd_sc_hd__tapvpwrvgnd_1
XTAP_TAPCELL_ROW_71_313 VGND VDPWR sky130_fd_sc_hd__tapvpwrvgnd_1
XFILLER_64_112 VGND VGND VDPWR VDPWR sky130_fd_sc_hd__fill_2
X_1230_ _1230_/A _1230_/B _1230_/C VGND VGND VDPWR VDPWR _1230_/Y sky130_fd_sc_hd__nor3_1
X_1161_ _1410_/B wire92/X VGND VGND VDPWR VDPWR _1584_/C sky130_fd_sc_hd__nand2_1
X_1092_ _1570_/A _1791_/A VGND VGND VDPWR VDPWR _1092_/Y sky130_fd_sc_hd__nor2_1
X_1994_ _2132_/Q _2021_/A1 _2039_/B VGND VGND VDPWR VDPWR _1994_/Y sky130_fd_sc_hd__o21ai_1
X_1428_ _1624_/B _2037_/A _1656_/C VGND VGND VDPWR VDPWR wire84/A sky130_fd_sc_hd__nor3_1
XFILLER_43_307 VGND VGND VDPWR VDPWR sky130_fd_sc_hd__fill_1
XFILLER_55_189 VGND VGND VDPWR VDPWR sky130_fd_sc_hd__decap_3
X_1359_ _1498_/B _1410_/B wire92/A VGND VGND VDPWR VDPWR _1408_/B sky130_fd_sc_hd__nand3_1
XFILLER_34_69 VGND VGND VDPWR VDPWR sky130_fd_sc_hd__fill_1
Xclkload2 clkload2/A VGND VGND VDPWR VDPWR clkload2/Y sky130_fd_sc_hd__clkinv_16
Xwire139 _1556_/X VGND VGND VDPWR VDPWR uo_out[7] sky130_fd_sc_hd__buf_6
XFILLER_59_77 VGND VGND VDPWR VDPWR sky130_fd_sc_hd__decap_3
Xdelaybuf_16_clk delaybuf_16_clk/A VGND VGND VDPWR VDPWR delaybuf_16_clk/X sky130_fd_sc_hd__clkbuf_2
XFILLER_46_167 VGND VGND VDPWR VDPWR sky130_fd_sc_hd__decap_3
XFILLER_46_189 VGND VGND VDPWR VDPWR sky130_fd_sc_hd__fill_1
XFILLER_61_148 VGND VGND VDPWR VDPWR sky130_fd_sc_hd__decap_3
Xu_sub.u_core.u_regfile.g_word\[4\].g_byte\[2\].u_cg.u_icg clkbuf_leaf_3_clk/X _1547_/Y
+ VGND VGND VDPWR VDPWR u_sub.u_core.u_regfile.g_word\[4\].g_byte\[2\].u_lat/GATE
+ sky130_fd_sc_hd__dlclkp_1
X_1213_ _1213_/A _1213_/B VGND VGND VDPWR VDPWR _1337_/B sky130_fd_sc_hd__or2_1
XFILLER_37_112 VGND VGND VDPWR VDPWR sky130_fd_sc_hd__decap_3
XTAP_TAPCELL_ROW_47_195 VGND VDPWR sky130_fd_sc_hd__tapvpwrvgnd_1
X_2193_ _2193_/CLK _2193_/D VGND VGND VDPWR VDPWR hold38/A sky130_fd_sc_hd__dfxtp_1
X_1144_ _1103_/A _1132_/A _1169_/A VGND VGND VDPWR VDPWR _1144_/Y sky130_fd_sc_hd__a21oi_1
X_1075_ _1616_/A _1075_/B VGND VGND VDPWR VDPWR _1076_/C sky130_fd_sc_hd__nand2_1
XFILLER_60_181 VGND VGND VDPWR VDPWR sky130_fd_sc_hd__fill_1
XFILLER_60_192 VGND VGND VDPWR VDPWR sky130_fd_sc_hd__fill_1
X_1977_ hold21/A _2038_/A _1932_/B _1976_/Y VGND VGND VDPWR VDPWR _2128_/D sky130_fd_sc_hd__a31oi_1
XPHY_EDGE_ROW_20_2_2_Right_39 VGND VDPWR sky130_fd_sc_hd__tapvpwrvgnd_1
Xhold25 hold25/A VGND VGND VDPWR VDPWR hold25/X sky130_fd_sc_hd__dlygate4sd3_1
Xhold36 hold36/A VGND VGND VDPWR VDPWR hold36/X sky130_fd_sc_hd__dlygate4sd3_1
Xhold47 hold47/A VGND VGND VDPWR VDPWR hold47/X sky130_fd_sc_hd__dlygate4sd3_1
Xhold58 hold58/A VGND VGND VDPWR VDPWR hold58/X sky130_fd_sc_hd__dlygate4sd3_1
XFILLER_45_35 VGND VGND VDPWR VDPWR sky130_fd_sc_hd__decap_3
XFILLER_45_68 VGND VGND VDPWR VDPWR sky130_fd_sc_hd__fill_1
XFILLER_34_137 VGND VGND VDPWR VDPWR sky130_fd_sc_hd__fill_2
XFILLER_42_170 VGND VGND VDPWR VDPWR sky130_fd_sc_hd__fill_1
X_1900_ _1900_/A _1900_/B VGND VGND VDPWR VDPWR _2113_/D sky130_fd_sc_hd__nor2_1
X_1831_ _1852_/A _1814_/Y _1828_/Y _1830_/Y VGND VGND VDPWR VDPWR _1831_/Y sky130_fd_sc_hd__o22ai_1
X_1762_ _1017_/Y wire96/X _1761_/Y VGND VGND VDPWR VDPWR _2081_/D sky130_fd_sc_hd__o21ai_1
X_1693_ _2071_/Q _2070_/Q _1690_/Y _1714_/B _2059_/Q VGND VGND VDPWR VDPWR _1694_/A
+ sky130_fd_sc_hd__a32oi_1
XFILLER_32_1 VGND VGND VDPWR VDPWR sky130_fd_sc_hd__decap_3
X_2176_ _2178_/CLK _2176_/D _2044_/A VGND VGND VDPWR VDPWR hold59/A sky130_fd_sc_hd__dfrtp_1
X_1127_ _1129_/A _1127_/B VGND VGND VDPWR VDPWR _1498_/C sky130_fd_sc_hd__nor2_1
X_1058_ _1188_/A _1141_/B _1141_/C VGND VGND VDPWR VDPWR _1058_/Y sky130_fd_sc_hd__a21oi_1
XFILLER_48_218 VGND VGND VDPWR VDPWR sky130_fd_sc_hd__decap_3
Xu_sub.u_core.u_regfile.g_nibsel\[3\].g_nib\[1\].u_m2 u_sub.u_core.u_regfile.g_nibsel\[3\].g_nib\[1\].u_lo/X
+ u_sub.u_core.u_regfile.g_nibsel\[3\].g_nib\[1\].u_hi/X max_cap1/X VGND VGND VDPWR
+ VDPWR u_sub.u_core.u_regfile.g_port\[1\].u_b/A2 sky130_fd_sc_hd__mux2_1
XTAP_TAPCELL_ROW_66_290 VGND VDPWR sky130_fd_sc_hd__tapvpwrvgnd_1
XTAP_TAPCELL_ROW_49_202 VGND VDPWR sky130_fd_sc_hd__tapvpwrvgnd_1
X_2030_ _2141_/Q _2027_/A _2142_/Q VGND VGND VDPWR VDPWR _2032_/A sky130_fd_sc_hd__a21oi_1
XFILLER_47_262 VGND VGND VDPWR VDPWR sky130_fd_sc_hd__fill_1
X_1814_ _1814_/A _1814_/B VGND VGND VDPWR VDPWR _1814_/Y sky130_fd_sc_hd__nor2_1
X_1745_ _1739_/Y _1756_/C _1750_/B VGND VGND VDPWR VDPWR _1748_/A sky130_fd_sc_hd__a21oi_1
X_1676_ _2059_/Q _1676_/B _1942_/A _1691_/B VGND VGND VDPWR VDPWR wire71/A sky130_fd_sc_hd__nor4_1
XFILLER_38_240 VGND VGND VDPWR VDPWR sky130_fd_sc_hd__decap_3
XFILLER_38_273 VGND VGND VDPWR VDPWR sky130_fd_sc_hd__fill_1
XFILLER_53_210 VGND VGND VDPWR VDPWR sky130_fd_sc_hd__decap_3
X_2228_ _2230_/A VGND VGND VDPWR VDPWR uio_oe[1] sky130_fd_sc_hd__buf_2
X_2159_ _2160_/CLK _2159_/D rst_n VGND VGND VDPWR VDPWR hold51/A sky130_fd_sc_hd__dfrtp_1
XFILLER_67_33 VGND VGND VDPWR VDPWR sky130_fd_sc_hd__fill_1
XPHY_EDGE_ROW_79_Left_138 VGND VDPWR sky130_fd_sc_hd__tapvpwrvgnd_1
XFILLER_44_221 VGND VGND VDPWR VDPWR sky130_fd_sc_hd__decap_3
XFILLER_44_265 VGND VGND VDPWR VDPWR sky130_fd_sc_hd__decap_3
XFILLER_44_276 VGND VGND VDPWR VDPWR sky130_fd_sc_hd__decap_3
XFILLER_44_287 VGND VGND VDPWR VDPWR sky130_fd_sc_hd__fill_1
XFILLER_8_188 VGND VGND VDPWR VDPWR sky130_fd_sc_hd__decap_3
X_1530_ _1532_/A _1552_/A VGND VGND VDPWR VDPWR _1530_/Y sky130_fd_sc_hd__nor2_1
X_1461_ _1461_/A _1461_/B _1461_/C VGND VGND VDPWR VDPWR _1462_/C sky130_fd_sc_hd__nor3_1
X_1392_ _1403_/A _1392_/B _1806_/A VGND VGND VDPWR VDPWR wire7/A sky130_fd_sc_hd__nor3_1
X_2013_ _2219_/Q _2013_/B VGND VGND VDPWR VDPWR _2013_/X sky130_fd_sc_hd__xor2_1
XFILLER_50_202 VGND VGND VDPWR VDPWR sky130_fd_sc_hd__fill_2
XTAP_TAPCELL_ROW_52_219 VGND VDPWR sky130_fd_sc_hd__tapvpwrvgnd_1
Xhold144 _2101_/Q VGND VGND VDPWR VDPWR _1861_/A sky130_fd_sc_hd__dlygate4sd3_1
X_1728_ _2071_/Q _2070_/Q VGND VGND VDPWR VDPWR _1729_/B sky130_fd_sc_hd__xor2_1
Xu_sub.u_core.u_regfile.g_port\[2\].u_b u_sub.u_core.u_regfile.g_port\[2\].u_b/A0
+ u_sub.u_core.u_regfile.g_port\[2\].u_b/A1 u_sub.u_core.u_regfile.g_port\[2\].u_b/A2
+ u_sub.u_core.u_regfile.g_port\[2\].u_b/A3 _1349_/Y _1431_/Y VGND VGND VDPWR VDPWR
+ u_sub.u_core.u_regfile.g_port\[2\].u_b/X tg_mux4_x1
X_1659_ _1723_/C _1658_/Y _2052_/Q VGND VGND VDPWR VDPWR _1660_/B sky130_fd_sc_hd__a21oi_1
XFILLER_4_191 VGND VGND VDPWR VDPWR sky130_fd_sc_hd__decap_3
XPHY_EDGE_ROW_14_2_2_Right_33 VGND VDPWR sky130_fd_sc_hd__tapvpwrvgnd_1
Xclkbuf_leaf_4_clk delaybuf_16_clk/X VGND VGND VDPWR VDPWR clkload2/A sky130_fd_sc_hd__clkbuf_2
X_1513_ _1513_/A _1544_/B VGND VGND VDPWR VDPWR _1532_/A sky130_fd_sc_hd__or2_1
X_1444_ _2151_/Q _2181_/Q _1443_/Y VGND VGND VDPWR VDPWR _1881_/B sky130_fd_sc_hd__o21a_1
X_1375_ _2151_/Q _1376_/B _1798_/A _2127_/Q _2125_/Q VGND VGND VDPWR VDPWR _1375_/Y
+ sky130_fd_sc_hd__o41ai_1
XTAP_TAPCELL_ROW_80_358 VGND VDPWR sky130_fd_sc_hd__tapvpwrvgnd_1
XFILLER_58_176 VGND VGND VDPWR VDPWR sky130_fd_sc_hd__fill_1
XTAP_TAPCELL_ROW_71_314 VGND VDPWR sky130_fd_sc_hd__tapvpwrvgnd_1
XFILLER_37_305 VGND VGND VDPWR VDPWR sky130_fd_sc_hd__fill_1
XFILLER_49_165 VGND VGND VDPWR VDPWR sky130_fd_sc_hd__decap_3
X_1160_ _1160_/A _1160_/B _1160_/C _1160_/D VGND VGND VDPWR VDPWR wire92/A sky130_fd_sc_hd__nor4_1
X_1091_ _2163_/Q _1520_/A VGND VGND VDPWR VDPWR _1095_/A sky130_fd_sc_hd__nand2_1
XFILLER_60_341 VGND VGND VDPWR VDPWR sky130_fd_sc_hd__decap_3
Xu_sub.u_core.u_regfile.g_port\[1\].u_a u_sub.u_core.u_regfile.g_port\[1\].u_b/A0
+ u_sub.u_core.u_regfile.g_port\[1\].u_b/A1 u_sub.u_core.u_regfile.g_port\[1\].u_b/A2
+ u_sub.u_core.u_regfile.g_port\[1\].u_b/A3 wire93/X _1430_/X VGND VGND VDPWR VDPWR
+ u_sub.u_core.u_regfile.g_port\[1\].u_a/X tg_mux4_x1
X_1993_ _1997_/B _1993_/B VGND VGND VDPWR VDPWR _2013_/B sky130_fd_sc_hd__nand2_1
XFILLER_62_1 VGND VGND VDPWR VDPWR sky130_fd_sc_hd__fill_2
XFILLER_55_124 VGND VGND VDPWR VDPWR sky130_fd_sc_hd__decap_3
X_1427_ _2052_/Q _1723_/C wire86/X _1653_/C VGND VGND VDPWR VDPWR _1656_/C sky130_fd_sc_hd__nand4b_1
X_1358_ _1485_/A _1584_/A _1584_/C VGND VGND VDPWR VDPWR _1483_/B sky130_fd_sc_hd__nor3_1
X_1289_ _1033_/A _1169_/A _1185_/Y _1278_/A VGND VGND VDPWR VDPWR _1289_/Y sky130_fd_sc_hd__a22oi_1
Xclkload3 clkload3/A VGND VGND VDPWR VDPWR clkload3/Y sky130_fd_sc_hd__clkinv_16
Xwire129 _2058_/Q VGND VGND VDPWR VDPWR wire129/X sky130_fd_sc_hd__buf_12
XFILLER_46_124 VGND VGND VDPWR VDPWR sky130_fd_sc_hd__decap_3
XFILLER_46_135 VGND VGND VDPWR VDPWR sky130_fd_sc_hd__fill_1
XFILLER_46_157 VGND VGND VDPWR VDPWR sky130_fd_sc_hd__decap_3
XFILLER_61_127 VGND VGND VDPWR VDPWR sky130_fd_sc_hd__decap_3
Xdelaybuf_9_clk delaybuf_9_clk/A VGND VGND VDPWR VDPWR delaybuf_9_clk/X sky130_fd_sc_hd__clkbuf_2
Xu_sub.u_core.u_regfile.g_nibsel\[3\].g_nib\[3\].u_hi u_sub.u_core.u_regfile.g_word\[3\].g_byte\[2\].u_lat/Q3
+ u_sub.u_core.u_regfile.g_word\[3\].g_byte\[2\].u_lat/Q7 u_sub.u_core.u_regfile.g_word\[3\].g_byte\[3\].u_lat/Q3
+ u_sub.u_core.u_regfile.g_word\[3\].g_byte\[3\].u_lat/Q7 max_cap4/X max_cap2/X VGND
+ VGND VDPWR VDPWR u_sub.u_core.u_regfile.g_nibsel\[3\].g_nib\[3\].u_hi/X tg_mux4_x1
X_2192_ _2193_/CLK _2192_/D VGND VGND VDPWR VDPWR hold52/A sky130_fd_sc_hd__dfxtp_1
X_1212_ _1212_/A _1212_/B VGND VGND VDPWR VDPWR _1214_/B sky130_fd_sc_hd__nand2_1
XFILLER_37_146 VGND VGND VDPWR VDPWR sky130_fd_sc_hd__decap_3
XFILLER_37_157 VGND VGND VDPWR VDPWR sky130_fd_sc_hd__decap_3
XTAP_TAPCELL_ROW_47_196 VGND VDPWR sky130_fd_sc_hd__tapvpwrvgnd_1
X_1143_ _1141_/B _1046_/C _1599_/C _1142_/Y VGND VGND VDPWR VDPWR _1143_/X sky130_fd_sc_hd__o31a_1
X_1074_ _1376_/B _1188_/A VGND VGND VDPWR VDPWR _1075_/B sky130_fd_sc_hd__nand2_1
X_1976_ hold21/A _1932_/B _2128_/Q VGND VGND VDPWR VDPWR _1976_/Y sky130_fd_sc_hd__a21oi_1
Xhold26 hold26/A VGND VGND VDPWR VDPWR hold26/X sky130_fd_sc_hd__dlygate4sd3_1
Xhold37 hold37/A VGND VGND VDPWR VDPWR hold37/X sky130_fd_sc_hd__dlygate4sd3_1
Xhold48 hold48/A VGND VGND VDPWR VDPWR hold48/X sky130_fd_sc_hd__dlygate4sd3_1
Xhold59 hold59/A VGND VGND VDPWR VDPWR hold59/X sky130_fd_sc_hd__dlygate4sd3_1
XFILLER_51_160 VGND VGND VDPWR VDPWR sky130_fd_sc_hd__fill_2
XFILLER_51_171 VGND VGND VDPWR VDPWR sky130_fd_sc_hd__decap_3
XFILLER_51_182 VGND VGND VDPWR VDPWR sky130_fd_sc_hd__decap_3
XFILLER_3_201 VGND VGND VDPWR VDPWR sky130_fd_sc_hd__fill_2
XPHY_EDGE_ROW_60_Left_119 VGND VDPWR sky130_fd_sc_hd__tapvpwrvgnd_1
XFILLER_42_160 VGND VGND VDPWR VDPWR sky130_fd_sc_hd__decap_3
XTAP_TAPCELL_ROW_44_177 VGND VDPWR sky130_fd_sc_hd__tapvpwrvgnd_1
X_1830_ _1263_/Y _1586_/X _1829_/Y VGND VGND VDPWR VDPWR _1830_/Y sky130_fd_sc_hd__o21ai_1
X_1761_ _1759_/X _1760_/Y wire96/X VGND VGND VDPWR VDPWR _1761_/Y sky130_fd_sc_hd__o21ai_1
X_1692_ _2213_/D _1717_/B VGND VGND VDPWR VDPWR _1714_/B sky130_fd_sc_hd__nand2_1
XFILLER_57_208 VGND VGND VDPWR VDPWR sky130_fd_sc_hd__fill_2
XFILLER_57_219 VGND VGND VDPWR VDPWR sky130_fd_sc_hd__decap_3
X_2175_ _2175_/CLK _2175_/D _2039_/B VGND VGND VDPWR VDPWR hold53/A sky130_fd_sc_hd__dfrtp_1
X_1126_ _1584_/A _1584_/B VGND VGND VDPWR VDPWR _1137_/A sky130_fd_sc_hd__nor2_1
X_1057_ _1376_/B _1057_/B VGND VGND VDPWR VDPWR _1141_/C sky130_fd_sc_hd__nand2b_1
X_1959_ _1959_/A hold39/A VGND VGND VDPWR VDPWR _1959_/Y sky130_fd_sc_hd__nor2b_1
XTAP_TAPCELL_ROW_58_247 VGND VDPWR sky130_fd_sc_hd__tapvpwrvgnd_1
XTAP_TAPCELL_ROW_66_291 VGND VDPWR sky130_fd_sc_hd__tapvpwrvgnd_1
XTAP_TAPCELL_ROW_49_203 VGND VDPWR sky130_fd_sc_hd__tapvpwrvgnd_1
XFILLER_62_200 VGND VGND VDPWR VDPWR sky130_fd_sc_hd__decap_3
Xclkbuf_0_clk clk VGND VGND VDPWR VDPWR clkbuf_0_clk/X sky130_fd_sc_hd__clkbuf_2
Xmax_cap91 _1560_/A VGND VGND VDPWR VDPWR _1827_/A sky130_fd_sc_hd__buf_6
X_1813_ _1950_/A _1814_/B VGND VGND VDPWR VDPWR _1813_/X sky130_fd_sc_hd__or2_1
X_1744_ _1747_/A _1744_/B VGND VGND VDPWR VDPWR _1756_/C sky130_fd_sc_hd__nand2_1
X_1675_ _2059_/Q _1675_/B _1881_/D VGND VGND VDPWR VDPWR _1687_/B sky130_fd_sc_hd__nand3b_1
X_2227_ _2230_/A VGND VGND VDPWR VDPWR uio_oe[0] sky130_fd_sc_hd__buf_2
X_2158_ clkload7/A _2158_/D _2044_/A VGND VGND VDPWR VDPWR _2158_/Q sky130_fd_sc_hd__dfrtp_1
X_2089_ clkload5/A _2089_/D VGND VGND VDPWR VDPWR _2089_/Q sky130_fd_sc_hd__dfxtp_1
X_1109_ _1757_/A _1590_/B VGND VGND VDPWR VDPWR _1109_/Y sky130_fd_sc_hd__nor2_1
XTAP_TAPCELL_ROW_63_272 VGND VDPWR sky130_fd_sc_hd__tapvpwrvgnd_1
XFILLER_44_233 VGND VGND VDPWR VDPWR sky130_fd_sc_hd__fill_2
Xclkbuf_0_u_sub.u_timer.g_cmp\[1\].g clkbuf_0_u_sub.u_timer.g_cmp\[1\].g/A VGND VGND
+ VDPWR VDPWR clkbuf_0_u_sub.u_timer.g_cmp\[1\].g/X sky130_fd_sc_hd__clkbuf_2
XFILLER_32_81 VGND VGND VDPWR VDPWR sky130_fd_sc_hd__decap_3
X_1460_ _1841_/S _2158_/Q VGND VGND VDPWR VDPWR _1461_/C sky130_fd_sc_hd__nand2_1
X_1391_ _1624_/B _2037_/A _1391_/C VGND VGND VDPWR VDPWR _1391_/Y sky130_fd_sc_hd__nor3_1
XTAP_TAPCELL_ROW_77_342 VGND VDPWR sky130_fd_sc_hd__tapvpwrvgnd_1
X_2012_ _2221_/Q _2012_/B VGND VGND VDPWR VDPWR _2020_/A sky130_fd_sc_hd__xnor2_1
Xhold145 _2083_/Q VGND VGND VDPWR VDPWR _1766_/A sky130_fd_sc_hd__dlygate4sd3_1
X_1727_ _2070_/Q _1727_/B VGND VGND VDPWR VDPWR _2070_/D sky130_fd_sc_hd__nor2_1
X_1658_ _1658_/A _1658_/B VGND VGND VDPWR VDPWR _1658_/Y sky130_fd_sc_hd__nand2_1
X_1589_ _2088_/Q _1121_/D _1590_/B VGND VGND VDPWR VDPWR _1827_/B sky130_fd_sc_hd__mux2_1
XFILLER_49_314 VGND VGND VDPWR VDPWR sky130_fd_sc_hd__decap_3
XFILLER_17_200 VGND VGND VDPWR VDPWR sky130_fd_sc_hd__fill_1
XFILLER_17_222 VGND VGND VDPWR VDPWR sky130_fd_sc_hd__fill_1
XFILLER_49_336 VGND VGND VDPWR VDPWR sky130_fd_sc_hd__fill_1
Xclkbuf_0_u_sub.u_timer.u_cg_wd.gclk_o u_sub.u_timer.u_cg_wd.u_icg/GCLK VGND VGND
+ VDPWR VDPWR clkbuf_0_u_sub.u_timer.u_cg_wd.gclk_o/X sky130_fd_sc_hd__clkbuf_2
Xu_sub.u_core.u_regfile.g_word\[1\].g_byte\[0\].u_lat max_cap121/X max_cap119/X wire116/A
+ max_cap115/X wire112/A max_cap111/X max_cap109/X max_cap107/X u_sub.u_core.u_regfile.g_word\[1\].g_byte\[0\].u_lat/GATE
+ VGND VDPWR u_sub.u_core.u_regfile.g_word\[1\].g_byte\[0\].u_lat/Q0 u_sub.u_core.u_regfile.g_word\[1\].g_byte\[0\].u_lat/Q1
+ u_sub.u_core.u_regfile.g_word\[1\].g_byte\[0\].u_lat/Q2 u_sub.u_core.u_regfile.g_word\[1\].g_byte\[0\].u_lat/Q3
+ u_sub.u_core.u_regfile.g_word\[1\].g_byte\[0\].u_lat/Q4 u_sub.u_core.u_regfile.g_word\[1\].g_byte\[0\].u_lat/Q5
+ u_sub.u_core.u_regfile.g_word\[1\].g_byte\[0\].u_lat/Q6 u_sub.u_core.u_regfile.g_word\[1\].g_byte\[0\].u_lat/Q7
+ dlxtp8_x1
X_1512_ _1534_/C _1512_/B VGND VGND VDPWR VDPWR _1544_/B sky130_fd_sc_hd__nand2b_1
X_1443_ _2165_/Q _2151_/Q VGND VGND VDPWR VDPWR _1443_/Y sky130_fd_sc_hd__nand2b_1
X_1374_ _1403_/A _1392_/B VGND VGND VDPWR VDPWR _1966_/D sky130_fd_sc_hd__nand2b_1
XFILLER_23_214 VGND VGND VDPWR VDPWR sky130_fd_sc_hd__decap_3
XTAP_TAPCELL_ROW_80_359 VGND VDPWR sky130_fd_sc_hd__tapvpwrvgnd_1
XFILLER_48_69 VGND VGND VDPWR VDPWR sky130_fd_sc_hd__fill_2
XFILLER_58_111 VGND VGND VDPWR VDPWR sky130_fd_sc_hd__decap_3
XFILLER_58_144 VGND VGND VDPWR VDPWR sky130_fd_sc_hd__decap_3
XFILLER_58_155 VGND VGND VDPWR VDPWR sky130_fd_sc_hd__decap_3
XFILLER_14_203 VGND VGND VDPWR VDPWR sky130_fd_sc_hd__fill_2
XTAP_TAPCELL_ROW_71_315 VGND VDPWR sky130_fd_sc_hd__tapvpwrvgnd_1
XFILLER_49_177 VGND VGND VDPWR VDPWR sky130_fd_sc_hd__fill_1
XFILLER_64_147 VGND VGND VDPWR VDPWR sky130_fd_sc_hd__decap_3
X_1090_ _1570_/A _1791_/A VGND VGND VDPWR VDPWR _1204_/B sky130_fd_sc_hd__nand2_1
Xclkload10 _2160_/CLK VGND VGND VDPWR VDPWR clkload10/Y sky130_fd_sc_hd__clkinv_4
Xu_sub.u_core.u_regfile.g_port\[1\].u_b u_sub.u_core.u_regfile.g_port\[1\].u_b/A0
+ u_sub.u_core.u_regfile.g_port\[1\].u_b/A1 u_sub.u_core.u_regfile.g_port\[1\].u_b/A2
+ u_sub.u_core.u_regfile.g_port\[1\].u_b/A3 _1349_/Y _1431_/Y VGND VGND VDPWR VDPWR
+ u_sub.u_core.u_regfile.g_port\[1\].u_b/X tg_mux4_x1
X_1992_ _2131_/Q _2130_/Q _2129_/Q _2132_/Q VGND VGND VDPWR VDPWR _1993_/B sky130_fd_sc_hd__a31o_1
XFILLER_55_103 VGND VGND VDPWR VDPWR sky130_fd_sc_hd__decap_3
XFILLER_55_136 VGND VGND VDPWR VDPWR sky130_fd_sc_hd__decap_3
XPHY_EDGE_ROW_21_2_2_Left_10 VGND VDPWR sky130_fd_sc_hd__tapvpwrvgnd_1
Xclkbuf_1_0__f_u_sub.u_core.u_cg_wb_hi.gclk_o clkbuf_0_u_sub.u_core.u_cg_wb_hi.gclk_o/X
+ VGND VGND VDPWR VDPWR _2099_/CLK sky130_fd_sc_hd__clkbuf_2
X_1426_ _1720_/A _1426_/B VGND VGND VDPWR VDPWR _1426_/Y sky130_fd_sc_hd__nor2_1
X_1357_ _2127_/Q _2126_/Q VGND VGND VDPWR VDPWR _1357_/X sky130_fd_sc_hd__or2_1
X_1288_ _1326_/A _1287_/Y _1286_/Y VGND VGND VDPWR VDPWR _1292_/A sky130_fd_sc_hd__a21oi_1
Xu_sub.u_core.u_regfile.g_nibsel\[4\].g_nib\[1\].u_hi u_sub.u_core.u_regfile.g_word\[4\].g_byte\[2\].u_lat/Q1
+ u_sub.u_core.u_regfile.g_word\[4\].g_byte\[2\].u_lat/Q5 u_sub.u_core.u_regfile.g_word\[4\].g_byte\[3\].u_lat/Q1
+ u_sub.u_core.u_regfile.g_word\[4\].g_byte\[3\].u_lat/Q5 max_cap5/X max_cap3/X VGND
+ VGND VDPWR VDPWR u_sub.u_core.u_regfile.g_nibsel\[4\].g_nib\[1\].u_hi/X tg_mux4_x1
Xclkload4 clkload4/A VGND VGND VDPWR VDPWR clkload4/Y sky130_fd_sc_hd__clkinv_8
XFILLER_59_35 VGND VGND VDPWR VDPWR sky130_fd_sc_hd__fill_1
XFILLER_37_136 VGND VGND VDPWR VDPWR sky130_fd_sc_hd__decap_3
X_2191_ _2194_/CLK _2191_/D VGND VGND VDPWR VDPWR hold48/A sky130_fd_sc_hd__dfxtp_1
X_1211_ _1211_/A _1211_/B VGND VGND VDPWR VDPWR _1211_/X sky130_fd_sc_hd__or2_1
X_1142_ _1142_/A _1142_/B _1142_/C VGND VGND VDPWR VDPWR _1142_/Y sky130_fd_sc_hd__nor3_1
X_1073_ _1593_/A _1757_/A _1593_/B VGND VGND VDPWR VDPWR _1213_/B sky130_fd_sc_hd__or3_1
X_1975_ _1934_/A _1935_/Y _1974_/Y VGND VGND VDPWR VDPWR _2127_/D sky130_fd_sc_hd__o21ai_1
XPHY_EDGE_ROW_49_Right_68 VGND VDPWR sky130_fd_sc_hd__tapvpwrvgnd_1
Xhold27 hold27/A VGND VGND VDPWR VDPWR hold27/X sky130_fd_sc_hd__dlygate4sd3_1
Xhold38 hold38/A VGND VGND VDPWR VDPWR hold38/X sky130_fd_sc_hd__dlygate4sd3_1
X_1409_ _1410_/A _1410_/B wire92/X VGND VGND VDPWR VDPWR _1586_/A sky130_fd_sc_hd__and3_1
XFILLER_43_106 VGND VGND VDPWR VDPWR sky130_fd_sc_hd__fill_1
XPHY_EDGE_ROW_22_2_2_Left_11 VGND VDPWR sky130_fd_sc_hd__tapvpwrvgnd_1
XPHY_EDGE_ROW_58_Right_77 VGND VDPWR sky130_fd_sc_hd__tapvpwrvgnd_1
Xhold49 hold49/A VGND VGND VDPWR VDPWR hold49/X sky130_fd_sc_hd__dlygate4sd3_1
XFILLER_61_58 VGND VGND VDPWR VDPWR sky130_fd_sc_hd__fill_1
XFILLER_3_235 VGND VGND VDPWR VDPWR sky130_fd_sc_hd__fill_1
XPHY_EDGE_ROW_67_Right_86 VGND VDPWR sky130_fd_sc_hd__tapvpwrvgnd_1
XPHY_EDGE_ROW_76_Right_95 VGND VDPWR sky130_fd_sc_hd__tapvpwrvgnd_1
Xclkbuf_regs_0_clk delaybuf_23_clk/X VGND VGND VDPWR VDPWR clkbuf_regs_0_clk/X sky130_fd_sc_hd__clkbuf_2
Xu_sub.u_core.u_regfile.g_port\[0\].u_a u_sub.u_core.u_regfile.g_port\[0\].u_b/A0
+ u_sub.u_core.u_regfile.g_port\[0\].u_b/A1 u_sub.u_core.u_regfile.g_port\[0\].u_b/A2
+ u_sub.u_core.u_regfile.g_port\[0\].u_b/A3 wire93/X _1430_/X VGND VGND VDPWR VDPWR
+ u_sub.u_core.u_regfile.g_port\[0\].u_a/X tg_mux4_x1
XFILLER_27_191 VGND VGND VDPWR VDPWR sky130_fd_sc_hd__decap_3
XTAP_TAPCELL_ROW_44_178 VGND VDPWR sky130_fd_sc_hd__tapvpwrvgnd_1
XFILLER_42_183 VGND VGND VDPWR VDPWR sky130_fd_sc_hd__decap_3
X_1760_ _1333_/X _1336_/B _1757_/X _1332_/X VGND VGND VDPWR VDPWR _1760_/Y sky130_fd_sc_hd__a211oi_1
X_1691_ _1691_/A _1691_/B VGND VGND VDPWR VDPWR _1717_/B sky130_fd_sc_hd__nor2_1
X_2174_ _2175_/CLK hold66/X hold20/X VGND VGND VDPWR VDPWR hold63/A sky130_fd_sc_hd__dfrtp_1
X_1125_ _1128_/C _1220_/A _1128_/A _1128_/B VGND VGND VDPWR VDPWR _1584_/B sky130_fd_sc_hd__nand4b_1
XFILLER_18_191 VGND VGND VDPWR VDPWR sky130_fd_sc_hd__decap_3
X_1056_ _1188_/A _1485_/C VGND VGND VDPWR VDPWR _1056_/Y sky130_fd_sc_hd__nor2_1
X_1958_ uio_out[3] _2118_/D VGND VGND VDPWR VDPWR _1958_/Y sky130_fd_sc_hd__nand2_1
X_1889_ _1889_/A _1889_/B VGND VGND VDPWR VDPWR _2110_/D sky130_fd_sc_hd__nor2_1
XTAP_TAPCELL_ROW_58_248 VGND VDPWR sky130_fd_sc_hd__tapvpwrvgnd_1
XFILLER_71_223 VGND VGND VDPWR VDPWR sky130_fd_sc_hd__fill_1
XPHY_EDGE_ROW_23_2_2_Left_12 VGND VDPWR sky130_fd_sc_hd__tapvpwrvgnd_1
XFILLER_47_231 VGND VGND VDPWR VDPWR sky130_fd_sc_hd__fill_1
XTAP_TAPCELL_ROW_49_204 VGND VDPWR sky130_fd_sc_hd__tapvpwrvgnd_1
XFILLER_62_289 VGND VGND VDPWR VDPWR sky130_fd_sc_hd__fill_1
Xu_sub.u_core.u_regfile.g_nibsel\[1\].g_nib\[0\].u_m2 u_sub.u_core.u_regfile.g_nibsel\[1\].g_nib\[0\].u_lo/X
+ u_sub.u_core.u_regfile.g_nibsel\[1\].g_nib\[0\].u_hi/X _1583_/Y VGND VGND VDPWR
+ VDPWR u_sub.u_core.u_regfile.g_port\[0\].u_b/A0 sky130_fd_sc_hd__mux2_1
X_1812_ uio_in[1] wire97/X _1807_/Y wire74/X VGND VGND VDPWR VDPWR _1814_/B sky130_fd_sc_hd__o22ai_1
X_1743_ _1566_/A _1750_/B _1740_/Y _1515_/B VGND VGND VDPWR VDPWR _2076_/D sky130_fd_sc_hd__a22o_1
X_1674_ _1676_/B _1942_/A VGND VGND VDPWR VDPWR _1881_/D sky130_fd_sc_hd__nor2_1
XFILLER_53_201 VGND VGND VDPWR VDPWR sky130_fd_sc_hd__fill_1
XFILLER_53_223 VGND VGND VDPWR VDPWR sky130_fd_sc_hd__decap_3
X_1039_ _1153_/C _1151_/B _1350_/A _1316_/B VGND VGND VDPWR VDPWR _1039_/Y sky130_fd_sc_hd__nor4_1
X_2157_ clkload8/A _2157_/D _2044_/A VGND VGND VDPWR VDPWR _2157_/Q sky130_fd_sc_hd__dfrtp_1
X_2088_ clkload5/A _2088_/D VGND VGND VDPWR VDPWR _2088_/Q sky130_fd_sc_hd__dfxtp_1
X_1108_ _1567_/B _1567_/C _1567_/D VGND VGND VDPWR VDPWR _1590_/B sky130_fd_sc_hd__nand3_1
XTAP_TAPCELL_ROW_63_273 VGND VDPWR sky130_fd_sc_hd__tapvpwrvgnd_1
XFILLER_67_35 VGND VGND VDPWR VDPWR sky130_fd_sc_hd__decap_3
XFILLER_44_245 VGND VGND VDPWR VDPWR sky130_fd_sc_hd__decap_3
XPHY_EDGE_ROW_24_2_2_Left_13 VGND VDPWR sky130_fd_sc_hd__tapvpwrvgnd_1
XFILLER_67_304 VGND VGND VDPWR VDPWR sky130_fd_sc_hd__fill_2
XFILLER_67_315 VGND VGND VDPWR VDPWR sky130_fd_sc_hd__fill_1
X_1390_ _2052_/Q _1390_/A2 _1723_/C _1389_/Y _1390_/B2 VGND VGND VDPWR VDPWR _1391_/C
+ sky130_fd_sc_hd__a32oi_1
XTAP_TAPCELL_ROW_77_343 VGND VDPWR sky130_fd_sc_hd__tapvpwrvgnd_1
X_2011_ hold62/X _2011_/B VGND VGND VDPWR VDPWR _2011_/X sky130_fd_sc_hd__xor2_1
XFILLER_50_248 VGND VGND VDPWR VDPWR sky130_fd_sc_hd__decap_3
Xhold146 _2089_/Q VGND VGND VDPWR VDPWR hold146/X sky130_fd_sc_hd__dlygate4sd3_1
X_1726_ _2071_/Q wire71/A _1729_/A VGND VGND VDPWR VDPWR _1727_/B sky130_fd_sc_hd__o21ai_1
X_1657_ _1657_/A1 _1429_/D _1869_/A VGND VGND VDPWR VDPWR _1658_/B sky130_fd_sc_hd__a21oi_1
X_1588_ _2080_/Q _1588_/B _1753_/C VGND VGND VDPWR VDPWR _1613_/C sky130_fd_sc_hd__nand3_1
XFILLER_37_16 VGND VGND VDPWR VDPWR sky130_fd_sc_hd__decap_3
XFILLER_37_38 VGND VGND VDPWR VDPWR sky130_fd_sc_hd__fill_2
X_2209_ _2210_/CLK _2209_/D VGND VGND VDPWR VDPWR hold30/A sky130_fd_sc_hd__dfxtp_1
XFILLER_26_234 VGND VGND VDPWR VDPWR sky130_fd_sc_hd__fill_2
Xu_sub.u_core.u_regfile.g_word\[4\].g_byte\[2\].u_lat max_cap121/X max_cap119/X wire116/A
+ max_cap115/X wire112/A max_cap111/X max_cap109/X max_cap107/X u_sub.u_core.u_regfile.g_word\[4\].g_byte\[2\].u_lat/GATE
+ VGND VDPWR u_sub.u_core.u_regfile.g_word\[4\].g_byte\[2\].u_lat/Q0 u_sub.u_core.u_regfile.g_word\[4\].g_byte\[2\].u_lat/Q1
+ u_sub.u_core.u_regfile.g_word\[4\].g_byte\[2\].u_lat/Q2 u_sub.u_core.u_regfile.g_word\[4\].g_byte\[2\].u_lat/Q3
+ u_sub.u_core.u_regfile.g_word\[4\].g_byte\[2\].u_lat/Q4 u_sub.u_core.u_regfile.g_word\[4\].g_byte\[2\].u_lat/Q5
+ u_sub.u_core.u_regfile.g_word\[4\].g_byte\[2\].u_lat/Q6 u_sub.u_core.u_regfile.g_word\[4\].g_byte\[2\].u_lat/Q7
+ dlxtp8_x1
XPHY_EDGE_ROW_25_2_2_Left_14 VGND VDPWR sky130_fd_sc_hd__tapvpwrvgnd_1
XFILLER_32_226 VGND VGND VDPWR VDPWR sky130_fd_sc_hd__fill_1
XFILLER_71_7 VGND VGND VDPWR VDPWR sky130_fd_sc_hd__decap_3
Xclkbuf_0_u_sub.u_core.u_cg_wb_hi.gclk_o u_sub.u_core.u_cg_wb_hi.u_icg/GCLK VGND VGND
+ VDPWR VDPWR clkbuf_0_u_sub.u_core.u_cg_wb_hi.gclk_o/X sky130_fd_sc_hd__clkbuf_2
X_1511_ _1403_/X _1405_/Y _1510_/X _1404_/Y _1352_/X VGND VGND VDPWR VDPWR _1534_/C
+ sky130_fd_sc_hd__a32oi_1
X_1442_ _1442_/A _1442_/B VGND VGND VDPWR VDPWR _1780_/A sky130_fd_sc_hd__nand2_1
XFILLER_55_307 VGND VGND VDPWR VDPWR sky130_fd_sc_hd__decap_3
X_1373_ _1403_/A wire97/X VGND VGND VDPWR VDPWR _1433_/B sky130_fd_sc_hd__nor2_1
X_1709_ _1709_/A _1709_/B VGND VGND VDPWR VDPWR _2064_/D sky130_fd_sc_hd__nor2_1
XFILLER_46_307 VGND VGND VDPWR VDPWR sky130_fd_sc_hd__fill_2
XFILLER_58_134 VGND VGND VDPWR VDPWR sky130_fd_sc_hd__fill_2
XFILLER_58_167 VGND VGND VDPWR VDPWR sky130_fd_sc_hd__decap_3
XFILLER_64_69 VGND VGND VDPWR VDPWR sky130_fd_sc_hd__fill_1
XTAP_TAPCELL_ROW_71_316 VGND VDPWR sky130_fd_sc_hd__tapvpwrvgnd_1
Xdelaybuf_19_clk delaybuf_19_clk/A VGND VGND VDPWR VDPWR delaybuf_20_clk/A sky130_fd_sc_hd__clkbuf_2
XFILLER_49_123 VGND VGND VDPWR VDPWR sky130_fd_sc_hd__fill_1
XPHY_EDGE_ROW_26_2_2_Left_15 VGND VDPWR sky130_fd_sc_hd__tapvpwrvgnd_1
XTAP_TAPCELL_ROW_11_2_2_140 VGND VDPWR sky130_fd_sc_hd__tapvpwrvgnd_1
Xclkload11 _2175_/CLK VGND VGND VDPWR VDPWR clkload11/Y sky130_fd_sc_hd__clkinv_1
X_1991_ _2132_/Q _2131_/Q _2130_/Q _2129_/Q VGND VGND VDPWR VDPWR _1997_/B sky130_fd_sc_hd__nand4_1
X_1425_ _2054_/Q _1426_/B VGND VGND VDPWR VDPWR _1425_/Y sky130_fd_sc_hd__nor2_1
X_1356_ _2127_/Q _2126_/Q VGND VGND VDPWR VDPWR _1936_/A sky130_fd_sc_hd__nor2_1
X_1287_ wire134/A _1280_/B _1791_/A VGND VGND VDPWR VDPWR _1287_/Y sky130_fd_sc_hd__a21oi_1
Xclkload5 clkload5/A VGND VGND VDPWR VDPWR clkload5/Y sky130_fd_sc_hd__inv_12
XFILLER_46_137 VGND VGND VDPWR VDPWR sky130_fd_sc_hd__fill_1
XFILLER_46_148 VGND VGND VDPWR VDPWR sky130_fd_sc_hd__decap_3
Xu_sub.u_core.u_regfile.g_ir\[3\].u_cg.u_icg clkload0/A _1553_/Y VGND VGND VDPWR VDPWR
+ u_sub.u_core.u_regfile.g_ir\[3\].u_lat/GATE sky130_fd_sc_hd__dlclkp_1
XFILLER_37_115 VGND VGND VDPWR VDPWR sky130_fd_sc_hd__decap_3
Xu_sub.u_core.u_regfile.g_nibsel\[3\].g_nib\[3\].u_lo u_sub.u_core.u_regfile.g_word\[3\].g_byte\[0\].u_lat/Q3
+ u_sub.u_core.u_regfile.g_word\[3\].g_byte\[0\].u_lat/Q7 u_sub.u_core.u_regfile.g_word\[3\].g_byte\[1\].u_lat/Q3
+ u_sub.u_core.u_regfile.g_word\[3\].g_byte\[1\].u_lat/Q7 max_cap4/X max_cap2/X VGND
+ VGND VDPWR VDPWR u_sub.u_core.u_regfile.g_nibsel\[3\].g_nib\[3\].u_lo/X tg_mux4_x1
X_2190_ _2194_/CLK hold50/X VGND VGND VDPWR VDPWR hold49/A sky130_fd_sc_hd__dfxtp_1
X_1210_ _1210_/A _1210_/B VGND VGND VDPWR VDPWR _1211_/B sky130_fd_sc_hd__xnor2_1
X_1141_ _1360_/B _1141_/B _1141_/C VGND VGND VDPWR VDPWR _1599_/C sky130_fd_sc_hd__nor3_1
X_1072_ _1593_/B VGND VGND VDPWR VDPWR _1215_/D sky130_fd_sc_hd__inv_1
XFILLER_33_343 VGND VGND VDPWR VDPWR sky130_fd_sc_hd__fill_2
XFILLER_45_192 VGND VGND VDPWR VDPWR sky130_fd_sc_hd__fill_2
XPHY_EDGE_ROW_27_2_2_Left_16 VGND VDPWR sky130_fd_sc_hd__tapvpwrvgnd_1
X_1974_ _2127_/Q _2118_/D VGND VGND VDPWR VDPWR _1974_/Y sky130_fd_sc_hd__nand2_1
XPHY_EDGE_ROW_26_2_2_Right_45 VGND VDPWR sky130_fd_sc_hd__tapvpwrvgnd_1
Xhold28 hold28/A VGND VGND VDPWR VDPWR hold28/X sky130_fd_sc_hd__dlygate4sd3_1
Xhold39 hold39/A VGND VGND VDPWR VDPWR hold39/X sky130_fd_sc_hd__dlygate4sd3_1
Xu_fpga VGND VDPWR _2048_/D _2049_/D _2108_/Q _2109_/Q wire132/X wire131/X wire130/X
+ wire129/X _2061_/Q _2062_/Q _2063_/Q _2064_/Q _2065_/Q _2066_/Q _2072_/Q u_fpga/clk
+ ui_in[1] ui_in[2] uio_in[6] uio_in[7] uio_oe[6] uio_oe[7] wire12/A wire10/A uo_out[1]
+ uo_out[2] wire105/X island
X_1408_ _1950_/A _1408_/B VGND VGND VDPWR VDPWR _1516_/A sky130_fd_sc_hd__nand2_1
XFILLER_36_181 VGND VGND VDPWR VDPWR sky130_fd_sc_hd__fill_1
X_1339_ _1339_/A _1339_/B VGND VGND VDPWR VDPWR _1339_/Y sky130_fd_sc_hd__xnor2_1
Xu_sub.u_core.u_regfile.g_nibsel\[1\].g_nib\[2\].u_hi u_sub.u_core.u_regfile.g_word\[1\].g_byte\[2\].u_lat/Q2
+ u_sub.u_core.u_regfile.g_word\[1\].g_byte\[2\].u_lat/Q6 u_sub.u_core.u_regfile.g_word\[1\].g_byte\[3\].u_lat/Q2
+ u_sub.u_core.u_regfile.g_word\[1\].g_byte\[3\].u_lat/Q6 wire83/X max_cap82/X VGND
+ VGND VDPWR VDPWR u_sub.u_core.u_regfile.g_nibsel\[1\].g_nib\[2\].u_hi/X tg_mux4_x1
Xu_sub.u_core.u_regfile.g_port\[0\].u_b u_sub.u_core.u_regfile.g_port\[0\].u_b/A0
+ u_sub.u_core.u_regfile.g_port\[0\].u_b/A1 u_sub.u_core.u_regfile.g_port\[0\].u_b/A2
+ u_sub.u_core.u_regfile.g_port\[0\].u_b/A3 _1349_/Y _1431_/Y VGND VGND VDPWR VDPWR
+ u_sub.u_core.u_regfile.g_port\[0\].u_b/X tg_mux4_x1
XFILLER_42_140 VGND VGND VDPWR VDPWR sky130_fd_sc_hd__fill_2
XFILLER_42_151 VGND VGND VDPWR VDPWR sky130_fd_sc_hd__decap_3
XTAP_TAPCELL_ROW_44_179 VGND VDPWR sky130_fd_sc_hd__tapvpwrvgnd_1
X_1690_ _2061_/Q _2062_/Q _1690_/C VGND VGND VDPWR VDPWR _1690_/Y sky130_fd_sc_hd__nor3_1
XFILLER_32_4 VGND VGND VDPWR VDPWR sky130_fd_sc_hd__decap_3
Xclkbuf_0_u_sub.u_core.addr_gclk u_sub.u_core.u_cg_addr.u_icg/GCLK VGND VGND VDPWR
+ VDPWR clkbuf_0_u_sub.u_core.addr_gclk/X sky130_fd_sc_hd__clkbuf_2
X_2173_ _2178_/CLK hold55/X _2044_/A VGND VGND VDPWR VDPWR hold57/A sky130_fd_sc_hd__dfrtp_1
X_1124_ _1472_/A _1471_/B _1124_/C _1139_/A VGND VGND VDPWR VDPWR _1410_/B sky130_fd_sc_hd__nand4b_1
X_1055_ _1057_/B _1376_/B VGND VGND VDPWR VDPWR _1485_/C sky130_fd_sc_hd__nand2b_1
XPHY_EDGE_ROW_28_2_2_Left_17 VGND VDPWR sky130_fd_sc_hd__tapvpwrvgnd_1
X_1957_ _1934_/A _1956_/Y _1948_/Y VGND VGND VDPWR VDPWR _2121_/D sky130_fd_sc_hd__o21ai_1
X_1888_ _2110_/Q _1881_/X _1729_/A VGND VGND VDPWR VDPWR _1889_/B sky130_fd_sc_hd__o21ai_1
XFILLER_56_210 VGND VGND VDPWR VDPWR sky130_fd_sc_hd__fill_1
XTAP_TAPCELL_ROW_58_249 VGND VDPWR sky130_fd_sc_hd__tapvpwrvgnd_1
XTAP_TAPCELL_ROW_49_205 VGND VDPWR sky130_fd_sc_hd__tapvpwrvgnd_1
Xmax_cap82 _1574_/Y VGND VGND VDPWR VDPWR max_cap82/X sky130_fd_sc_hd__clkbuf_4
X_1811_ _1809_/Y _1810_/Y _1849_/A _1808_/Y VGND VGND VDPWR VDPWR wire75/A sky130_fd_sc_hd__a211oi_1
Xu_sub.u_core.u_regfile.g_word\[3\].g_byte\[1\].u_cg.u_icg delaybuf_15_clk/X _1541_/Y
+ VGND VGND VDPWR VDPWR u_sub.u_core.u_regfile.g_word\[3\].g_byte\[1\].u_lat/GATE
+ sky130_fd_sc_hd__dlclkp_1
X_1742_ _1174_/A _1750_/B _1741_/Y VGND VGND VDPWR VDPWR _2075_/D sky130_fd_sc_hd__a21oi_1
X_1673_ _1673_/A _1673_/B VGND VGND VDPWR VDPWR _2054_/D sky130_fd_sc_hd__nor2_1
XFILLER_38_243 VGND VGND VDPWR VDPWR sky130_fd_sc_hd__decap_3
XFILLER_53_213 VGND VGND VDPWR VDPWR sky130_fd_sc_hd__decap_3
XTAP_TAPCELL_ROW_63_274 VGND VDPWR sky130_fd_sc_hd__tapvpwrvgnd_1
X_1038_ _1166_/A _1179_/B VGND VGND VDPWR VDPWR _1348_/C sky130_fd_sc_hd__nor2_1
Xu_sub.u_core.u_regfile.g_word\[1\].g_byte\[3\].u_cg.u_icg clkbuf_leaf_3_clk/X _1532_/Y
+ VGND VGND VDPWR VDPWR u_sub.u_core.u_regfile.g_word\[1\].g_byte\[3\].u_lat/GATE
+ sky130_fd_sc_hd__dlclkp_1
X_2156_ clkload7/A _2156_/D _1729_/A VGND VGND VDPWR VDPWR _2156_/Q sky130_fd_sc_hd__dfrtp_1
X_2087_ clkload5/A _2087_/D VGND VGND VDPWR VDPWR _2087_/Q sky130_fd_sc_hd__dfxtp_1
X_1107_ _1215_/C _1567_/C _1567_/D VGND VGND VDPWR VDPWR _1110_/C sky130_fd_sc_hd__and3_1
XPHY_EDGE_ROW_29_2_2_Left_18 VGND VDPWR sky130_fd_sc_hd__tapvpwrvgnd_1
XFILLER_44_224 VGND VGND VDPWR VDPWR sky130_fd_sc_hd__decap_3
XPHY_EDGE_ROW_48_Left_107 VGND VDPWR sky130_fd_sc_hd__tapvpwrvgnd_1
XFILLER_44_268 VGND VGND VDPWR VDPWR sky130_fd_sc_hd__decap_3
XFILLER_44_279 VGND VGND VDPWR VDPWR sky130_fd_sc_hd__fill_1
XPHY_EDGE_ROW_57_Left_116 VGND VDPWR sky130_fd_sc_hd__tapvpwrvgnd_1
XTAP_TAPCELL_ROW_54_230 VGND VDPWR sky130_fd_sc_hd__tapvpwrvgnd_1
XFILLER_32_50 VGND VGND VDPWR VDPWR sky130_fd_sc_hd__decap_3
XFILLER_32_72 VGND VGND VDPWR VDPWR sky130_fd_sc_hd__decap_3
XPHY_EDGE_ROW_66_Left_125 VGND VDPWR sky130_fd_sc_hd__tapvpwrvgnd_1
XTAP_TAPCELL_ROW_77_344 VGND VDPWR sky130_fd_sc_hd__tapvpwrvgnd_1
X_2010_ _2021_/A1 _2011_/B _2009_/Y VGND VGND VDPWR VDPWR _2136_/D sky130_fd_sc_hd__a21oi_1
XPHY_EDGE_ROW_75_Left_134 VGND VDPWR sky130_fd_sc_hd__tapvpwrvgnd_1
X_1725_ _1658_/A _1724_/Y _1729_/A VGND VGND VDPWR VDPWR _2069_/D sky130_fd_sc_hd__a21boi_1
Xclkbuf_leaf_7_clk clkbuf_leaf_7_clk/A VGND VGND VDPWR VDPWR clkload0/A sky130_fd_sc_hd__clkbuf_2
Xhold147 _2088_/Q VGND VGND VDPWR VDPWR hold147/X sky130_fd_sc_hd__dlygate4sd3_1
X_1656_ _2069_/Q _1881_/B _1656_/C wire7/X VGND VGND VDPWR VDPWR _1658_/A sky130_fd_sc_hd__or4b_1
X_1587_ _1587_/A _1854_/B VGND VGND VDPWR VDPWR _1613_/B sky130_fd_sc_hd__nand2_1
XFILLER_26_202 VGND VGND VDPWR VDPWR sky130_fd_sc_hd__fill_2
XTAP_TAPCELL_ROW_68_300 VGND VDPWR sky130_fd_sc_hd__tapvpwrvgnd_1
X_2208_ _2210_/CLK _2208_/D VGND VGND VDPWR VDPWR hold31/A sky130_fd_sc_hd__dfxtp_1
Xclkbuf_1_0__f_u_sub.u_core.u_cg_wb_lo.gclk_o clkbuf_0_u_sub.u_core.u_cg_wb_lo.gclk_o/X
+ VGND VGND VDPWR VDPWR _2096_/CLK sky130_fd_sc_hd__clkbuf_2
X_2139_ _2160_/CLK _2139_/D VGND VGND VDPWR VDPWR _2139_/Q sky130_fd_sc_hd__dfxtp_1
XFILLER_41_216 VGND VGND VDPWR VDPWR sky130_fd_sc_hd__fill_1
XFILLER_49_305 VGND VGND VDPWR VDPWR sky130_fd_sc_hd__fill_1
XFILLER_17_213 VGND VGND VDPWR VDPWR sky130_fd_sc_hd__fill_1
XFILLER_17_235 VGND VGND VDPWR VDPWR sky130_fd_sc_hd__fill_1
XFILLER_64_319 VGND VGND VDPWR VDPWR sky130_fd_sc_hd__fill_2
XFILLER_4_194 VGND VGND VDPWR VDPWR sky130_fd_sc_hd__decap_3
X_1510_ _1510_/A _1510_/B VGND VGND VDPWR VDPWR _1510_/X sky130_fd_sc_hd__xor2_1
X_1441_ _1441_/A _1623_/C VGND VGND VDPWR VDPWR _1442_/B sky130_fd_sc_hd__nor2_1
X_1372_ wire97/X VGND VGND VDPWR VDPWR _1392_/B sky130_fd_sc_hd__inv_1
XFILLER_23_205 VGND VGND VDPWR VDPWR sky130_fd_sc_hd__decap_3
X_1708_ _2044_/A _1708_/B VGND VGND VDPWR VDPWR _1709_/B sky130_fd_sc_hd__nand2_1
X_1639_ wire97/X _1638_/Y _1619_/Y VGND VGND VDPWR VDPWR _1640_/B sky130_fd_sc_hd__a21oi_1
XFILLER_14_227 VGND VGND VDPWR VDPWR sky130_fd_sc_hd__decap_3
XFILLER_54_341 VGND VGND VDPWR VDPWR sky130_fd_sc_hd__decap_3
XFILLER_49_168 VGND VGND VDPWR VDPWR sky130_fd_sc_hd__fill_2
XFILLER_54_92 VGND VGND VDPWR VDPWR sky130_fd_sc_hd__decap_3
XFILLER_60_344 VGND VGND VDPWR VDPWR sky130_fd_sc_hd__fill_1
X_1990_ _2021_/A1 _2014_/B _1989_/Y VGND VGND VDPWR VDPWR _2131_/D sky130_fd_sc_hd__a21oi_1
X_1424_ _2053_/Q _1426_/B VGND VGND VDPWR VDPWR _1424_/Y sky130_fd_sc_hd__nor2_1
X_1355_ _2079_/Q _2151_/Q VGND VGND VDPWR VDPWR _1366_/A sky130_fd_sc_hd__nand2b_1
XFILLER_36_341 VGND VGND VDPWR VDPWR sky130_fd_sc_hd__decap_3
XFILLER_55_127 VGND VGND VDPWR VDPWR sky130_fd_sc_hd__decap_3
XFILLER_63_171 VGND VGND VDPWR VDPWR sky130_fd_sc_hd__fill_2
X_1286_ _1566_/A _1118_/A _1242_/A _1092_/Y VGND VGND VDPWR VDPWR _1286_/Y sky130_fd_sc_hd__a31oi_1
XFILLER_11_208 VGND VGND VDPWR VDPWR sky130_fd_sc_hd__decap_3
XFILLER_51_344 VGND VGND VDPWR VDPWR sky130_fd_sc_hd__fill_1
Xclkload6 clkload6/A VGND VGND VDPWR VDPWR clkload6/Y sky130_fd_sc_hd__inv_8
Xu_sub.u_core.u_regfile.g_nibsel\[4\].g_nib\[1\].u_lo u_sub.u_core.u_regfile.g_word\[4\].g_byte\[0\].u_lat/Q1
+ u_sub.u_core.u_regfile.g_word\[4\].g_byte\[0\].u_lat/Q5 u_sub.u_core.u_regfile.g_word\[4\].g_byte\[1\].u_lat/Q1
+ u_sub.u_core.u_regfile.g_word\[4\].g_byte\[1\].u_lat/Q5 max_cap5/X max_cap3/X VGND
+ VGND VDPWR VDPWR u_sub.u_core.u_regfile.g_nibsel\[4\].g_nib\[1\].u_lo/X tg_mux4_x1
Xu_sub.u_core.u_regfile.g_port\[2\].u_za u_sub.u_core.u_regfile.g_port\[2\].u_a/X
+ _1154_/Y VGND VGND VDPWR VDPWR _1600_/A1 sky130_fd_sc_hd__and2_1
XFILLER_46_127 VGND VGND VDPWR VDPWR sky130_fd_sc_hd__fill_2
Xu_sub.u_core.u_regfile.g_nibsel\[2\].g_nib\[0\].u_hi u_sub.u_core.u_regfile.g_word\[2\].g_byte\[2\].u_lat/Q0
+ u_sub.u_core.u_regfile.g_word\[2\].g_byte\[2\].u_lat/Q4 u_sub.u_core.u_regfile.g_word\[2\].g_byte\[3\].u_lat/Q0
+ u_sub.u_core.u_regfile.g_word\[2\].g_byte\[3\].u_lat/Q4 max_cap4/X max_cap2/X VGND
+ VGND VDPWR VDPWR u_sub.u_core.u_regfile.g_nibsel\[2\].g_nib\[0\].u_hi/X tg_mux4_x1
XFILLER_37_149 VGND VGND VDPWR VDPWR sky130_fd_sc_hd__fill_1
X_1140_ _1104_/A _1068_/Y _1132_/A VGND VGND VDPWR VDPWR _1140_/Y sky130_fd_sc_hd__o21ai_1
X_1071_ _1167_/B _1141_/C _1070_/Y VGND VGND VDPWR VDPWR _1593_/B sky130_fd_sc_hd__o21ai_1
X_1973_ hold23/A _2126_/Q _1435_/B _1915_/Y _1972_/Y VGND VGND VDPWR VDPWR _2126_/D
+ sky130_fd_sc_hd__o41ai_1
Xhold29 hold29/A VGND VGND VDPWR VDPWR hold29/X sky130_fd_sc_hd__dlygate4sd3_1
X_1407_ _2151_/Q _1483_/B VGND VGND VDPWR VDPWR _1839_/A sky130_fd_sc_hd__nor2_1
X_1338_ _1339_/A _1339_/B VGND VGND VDPWR VDPWR _1338_/Y sky130_fd_sc_hd__nor2b_1
XFILLER_36_160 VGND VGND VDPWR VDPWR sky130_fd_sc_hd__decap_3
X_1269_ _2165_/Q _1520_/A VGND VGND VDPWR VDPWR _1271_/A sky130_fd_sc_hd__nand2_1
XFILLER_51_174 VGND VGND VDPWR VDPWR sky130_fd_sc_hd__decap_3
XFILLER_51_185 VGND VGND VDPWR VDPWR sky130_fd_sc_hd__decap_3
XFILLER_51_196 VGND VGND VDPWR VDPWR sky130_fd_sc_hd__fill_1
XFILLER_3_226 VGND VGND VDPWR VDPWR sky130_fd_sc_hd__decap_3
XFILLER_42_163 VGND VGND VDPWR VDPWR sky130_fd_sc_hd__decap_3
XFILLER_65_200 VGND VGND VDPWR VDPWR sky130_fd_sc_hd__decap_3
X_2172_ _2178_/CLK hold59/X _2044_/A VGND VGND VDPWR VDPWR hold61/A sky130_fd_sc_hd__dfrtp_1
XFILLER_65_233 VGND VGND VDPWR VDPWR sky130_fd_sc_hd__fill_1
X_1123_ _1123_/A _1123_/B _1123_/C _1123_/D VGND VGND VDPWR VDPWR _1471_/B sky130_fd_sc_hd__or4_1
X_1054_ _1057_/B _1376_/B VGND VGND VDPWR VDPWR _1054_/Y sky130_fd_sc_hd__nor2b_1
X_1956_ _1956_/A1 _1936_/Y _1955_/Y VGND VGND VDPWR VDPWR _1956_/Y sky130_fd_sc_hd__a21oi_1
X_1887_ _2214_/D _1890_/B VGND VGND VDPWR VDPWR _1889_/A sky130_fd_sc_hd__nor2_1
XFILLER_47_200 VGND VGND VDPWR VDPWR sky130_fd_sc_hd__fill_1
XTAP_TAPCELL_ROW_49_206 VGND VDPWR sky130_fd_sc_hd__tapvpwrvgnd_1
XFILLER_47_255 VGND VGND VDPWR VDPWR sky130_fd_sc_hd__fill_1
XFILLER_47_299 VGND VGND VDPWR VDPWR sky130_fd_sc_hd__decap_3
XFILLER_62_203 VGND VGND VDPWR VDPWR sky130_fd_sc_hd__fill_1
Xmax_cap72 _1436_/Y VGND VGND VDPWR VDPWR _2118_/D sky130_fd_sc_hd__clkbuf_4
Xmax_cap94 wire95/X VGND VGND VDPWR VDPWR _1343_/B sky130_fd_sc_hd__clkbuf_2
XFILLER_30_188 VGND VGND VDPWR VDPWR sky130_fd_sc_hd__decap_3
X_1810_ _2104_/Q wire7/X _1881_/B VGND VGND VDPWR VDPWR _1810_/Y sky130_fd_sc_hd__nand3_1
X_1741_ _1174_/A _1739_/Y _1750_/B VGND VGND VDPWR VDPWR _1741_/Y sky130_fd_sc_hd__a21oi_1
Xclkbuf_0_u_sub.u_core.u_cg_wb_lo.gclk_o u_sub.u_core.u_cg_wb_lo.u_icg/GCLK VGND VGND
+ VDPWR VDPWR clkbuf_0_u_sub.u_core.u_cg_wb_lo.gclk_o/X sky130_fd_sc_hd__clkbuf_2
X_1672_ _2054_/Q _1672_/B VGND VGND VDPWR VDPWR _1673_/B sky130_fd_sc_hd__nor2_1
XFILLER_38_222 VGND VGND VDPWR VDPWR sky130_fd_sc_hd__fill_2
X_2155_ clkload8/A _2155_/D _2044_/A VGND VGND VDPWR VDPWR _2155_/Q sky130_fd_sc_hd__dfrtp_1
X_1106_ _1485_/B _1127_/B _1103_/Y _1052_/A VGND VGND VDPWR VDPWR _1567_/D sky130_fd_sc_hd__a2bb2oi_1
XTAP_TAPCELL_ROW_63_275 VGND VDPWR sky130_fd_sc_hd__tapvpwrvgnd_1
X_1037_ _1278_/A _1121_/D VGND VGND VDPWR VDPWR _1348_/B sky130_fd_sc_hd__nor2b_1
X_2086_ clkload5/A _2086_/D VGND VGND VDPWR VDPWR _2086_/Q sky130_fd_sc_hd__dfxtp_1
X_1939_ _2125_/Q _1939_/B VGND VGND VDPWR VDPWR _1939_/Y sky130_fd_sc_hd__nand2_1
XFILLER_29_200 VGND VGND VDPWR VDPWR sky130_fd_sc_hd__decap_3
XFILLER_29_222 VGND VGND VDPWR VDPWR sky130_fd_sc_hd__decap_3
XFILLER_44_203 VGND VGND VDPWR VDPWR sky130_fd_sc_hd__fill_1
XTAP_TAPCELL_ROW_54_231 VGND VDPWR sky130_fd_sc_hd__tapvpwrvgnd_1
XFILLER_12_188 VGND VGND VDPWR VDPWR sky130_fd_sc_hd__decap_3
XFILLER_32_62 VGND VGND VDPWR VDPWR sky130_fd_sc_hd__decap_3
XTAP_TAPCELL_ROW_77_345 VGND VDPWR sky130_fd_sc_hd__tapvpwrvgnd_1
X_1724_ _1724_/A _1724_/B VGND VGND VDPWR VDPWR _1724_/Y sky130_fd_sc_hd__nand2_1
XTAP_TAPCELL_ROW_68_301 VGND VDPWR sky130_fd_sc_hd__tapvpwrvgnd_1
Xhold148 hold23/A VGND VGND VDPWR VDPWR _1432_/A sky130_fd_sc_hd__dlygate4sd3_1
X_1655_ _2107_/Q _1656_/C _1655_/C VGND VGND VDPWR VDPWR _1869_/A sky130_fd_sc_hd__nor3_1
X_1586_ _1586_/A wire85/X _1753_/C VGND VGND VDPWR VDPWR _1586_/X sky130_fd_sc_hd__or3_1
X_2207_ _2207_/CLK _2207_/D VGND VGND VDPWR VDPWR hold26/A sky130_fd_sc_hd__dfxtp_1
X_2138_ _2160_/CLK _2138_/D VGND VGND VDPWR VDPWR _2138_/Q sky130_fd_sc_hd__dfxtp_1
X_2069_ clkload4/A _2069_/D VGND VGND VDPWR VDPWR _2069_/Q sky130_fd_sc_hd__dfxtp_1
XFILLER_41_239 VGND VGND VDPWR VDPWR sky130_fd_sc_hd__decap_3
XTAP_TAPCELL_ROW_51_212 VGND VDPWR sky130_fd_sc_hd__tapvpwrvgnd_1
XFILLER_49_317 VGND VGND VDPWR VDPWR sky130_fd_sc_hd__fill_2
X_1440_ _2182_/Q _2166_/Q _1959_/A VGND VGND VDPWR VDPWR _1623_/C sky130_fd_sc_hd__mux2_1
X_1371_ _1371_/A _1371_/B VGND VGND VDPWR VDPWR wire97/A sky130_fd_sc_hd__nor2_1
XFILLER_68_91 VGND VGND VDPWR VDPWR sky130_fd_sc_hd__fill_2
XFILLER_23_217 VGND VGND VDPWR VDPWR sky130_fd_sc_hd__decap_3
X_1707_ _2064_/Q _1711_/C VGND VGND VDPWR VDPWR _1708_/B sky130_fd_sc_hd__nand2_1
X_1638_ _1806_/A _1629_/Y _1637_/Y VGND VGND VDPWR VDPWR _1638_/Y sky130_fd_sc_hd__a21oi_1
XFILLER_58_114 VGND VGND VDPWR VDPWR sky130_fd_sc_hd__fill_1
XFILLER_58_147 VGND VGND VDPWR VDPWR sky130_fd_sc_hd__decap_3
XFILLER_58_158 VGND VGND VDPWR VDPWR sky130_fd_sc_hd__decap_3
X_1569_ _1570_/B _1570_/C _1570_/A VGND VGND VDPWR VDPWR _1569_/Y sky130_fd_sc_hd__a21oi_1
XFILLER_54_331 VGND VGND VDPWR VDPWR sky130_fd_sc_hd__fill_1
XFILLER_66_191 VGND VGND VDPWR VDPWR sky130_fd_sc_hd__fill_2
XFILLER_49_103 VGND VGND VDPWR VDPWR sky130_fd_sc_hd__decap_3
XFILLER_57_180 VGND VGND VDPWR VDPWR sky130_fd_sc_hd__decap_3
XFILLER_64_106 VGND VGND VDPWR VDPWR sky130_fd_sc_hd__decap_3
XFILLER_60_323 VGND VGND VDPWR VDPWR sky130_fd_sc_hd__fill_1
XFILLER_9_232 VGND VGND VDPWR VDPWR sky130_fd_sc_hd__decap_3
XFILLER_55_106 VGND VGND VDPWR VDPWR sky130_fd_sc_hd__fill_2
X_1423_ _1426_/B VGND VGND VDPWR VDPWR _1423_/Y sky130_fd_sc_hd__inv_1
X_1354_ _1950_/A _2079_/Q VGND VGND VDPWR VDPWR _1549_/A sky130_fd_sc_hd__nor2_1
X_1285_ _1285_/A _1285_/B _1285_/C _2077_/Q VGND VGND VDPWR VDPWR _1285_/Y sky130_fd_sc_hd__nor4b_1
XFILLER_55_139 VGND VGND VDPWR VDPWR sky130_fd_sc_hd__decap_3
XFILLER_63_161 VGND VGND VDPWR VDPWR sky130_fd_sc_hd__decap_3
XFILLER_63_183 VGND VGND VDPWR VDPWR sky130_fd_sc_hd__fill_2
Xclkload7 clkload7/A VGND VGND VDPWR VDPWR clkload7/Y sky130_fd_sc_hd__clkinv_4
Xu_sub.u_core.u_regfile.g_port\[2\].u_zb u_sub.u_core.u_regfile.g_port\[2\].u_b/X
+ _1146_/X VGND VGND VDPWR VDPWR _1956_/A1 sky130_fd_sc_hd__and2_1
XFILLER_39_180 VGND VGND VDPWR VDPWR sky130_fd_sc_hd__fill_1
XFILLER_49_82 VGND VGND VDPWR VDPWR sky130_fd_sc_hd__fill_2
XPHY_EDGE_ROW_19_2_2_Left_8 VGND VDPWR sky130_fd_sc_hd__tapvpwrvgnd_1
XFILLER_37_139 VGND VGND VDPWR VDPWR sky130_fd_sc_hd__fill_1
XFILLER_60_120 VGND VGND VDPWR VDPWR sky130_fd_sc_hd__decap_3
X_1070_ _1056_/Y _1068_/Y _1132_/A VGND VGND VDPWR VDPWR _1070_/Y sky130_fd_sc_hd__o21ai_1
XFILLER_60_197 VGND VGND VDPWR VDPWR sky130_fd_sc_hd__decap_3
X_1972_ _1436_/Y _1970_/B _2126_/Q VGND VGND VDPWR VDPWR _1972_/Y sky130_fd_sc_hd__o21ai_1
XFILLER_53_1 VGND VGND VDPWR VDPWR sky130_fd_sc_hd__fill_2
X_1406_ _1403_/X _1405_/Y _1401_/Y VGND VGND VDPWR VDPWR _1406_/Y sky130_fd_sc_hd__a21boi_1
X_1337_ _1339_/B _1337_/B _1339_/A VGND VGND VDPWR VDPWR _1337_/Y sky130_fd_sc_hd__nor3b_1
X_1268_ _2181_/Q wire89/X VGND VGND VDPWR VDPWR _1268_/Y sky130_fd_sc_hd__nand2_1
X_1199_ _1199_/A _1199_/B _1331_/A VGND VGND VDPWR VDPWR _1202_/C sky130_fd_sc_hd__nor3_1
Xu_sub.u_core.u_regfile.g_nibsel\[1\].g_nib\[2\].u_lo u_sub.u_core.u_regfile.g_word\[1\].g_byte\[0\].u_lat/Q2
+ u_sub.u_core.u_regfile.g_word\[1\].g_byte\[0\].u_lat/Q6 u_sub.u_core.u_regfile.g_word\[1\].g_byte\[1\].u_lat/Q2
+ u_sub.u_core.u_regfile.g_word\[1\].g_byte\[1\].u_lat/Q6 wire83/X max_cap82/X VGND
+ VGND VDPWR VDPWR u_sub.u_core.u_regfile.g_nibsel\[1\].g_nib\[2\].u_lo/X tg_mux4_x1
XFILLER_27_194 VGND VGND VDPWR VDPWR sky130_fd_sc_hd__decap_3
XPHY_EDGE_ROW_45_Right_64 VGND VDPWR sky130_fd_sc_hd__tapvpwrvgnd_1
XFILLER_42_175 VGND VGND VDPWR VDPWR sky130_fd_sc_hd__fill_1
XFILLER_42_186 VGND VGND VDPWR VDPWR sky130_fd_sc_hd__fill_1
XFILLER_42_197 VGND VGND VDPWR VDPWR sky130_fd_sc_hd__decap_3
XPHY_EDGE_ROW_54_Right_73 VGND VDPWR sky130_fd_sc_hd__tapvpwrvgnd_1
X_2171_ _2175_/CLK hold53/X _2039_/B VGND VGND VDPWR VDPWR hold58/A sky130_fd_sc_hd__dfrtp_1
X_1122_ _1123_/A _1123_/B _1123_/C _1123_/D VGND VGND VDPWR VDPWR wire95/A sky130_fd_sc_hd__nor4_1
XFILLER_18_194 VGND VGND VDPWR VDPWR sky130_fd_sc_hd__decap_3
XPHY_EDGE_ROW_63_Right_82 VGND VDPWR sky130_fd_sc_hd__tapvpwrvgnd_1
X_1053_ _1076_/B _1053_/B VGND VGND VDPWR VDPWR _1060_/B sky130_fd_sc_hd__nand2_1
XPHY_EDGE_ROW_72_Right_91 VGND VDPWR sky130_fd_sc_hd__tapvpwrvgnd_1
X_1955_ _1963_/A _1955_/B VGND VGND VDPWR VDPWR _1955_/Y sky130_fd_sc_hd__nor2_1
X_1886_ _1886_/A _1886_/B VGND VGND VDPWR VDPWR _2109_/D sky130_fd_sc_hd__nor2_1
XFILLER_56_278 VGND VGND VDPWR VDPWR sky130_fd_sc_hd__fill_2
XFILLER_47_267 VGND VGND VDPWR VDPWR sky130_fd_sc_hd__decap_3
Xu_sub.u_core.u_regfile.g_word\[3\].g_byte\[1\].u_lat max_cap120/X max_cap118/X wire116/X
+ max_cap114/X wire112/X max_cap110/X max_cap108/X max_cap106/X u_sub.u_core.u_regfile.g_word\[3\].g_byte\[1\].u_lat/GATE
+ VGND VDPWR u_sub.u_core.u_regfile.g_word\[3\].g_byte\[1\].u_lat/Q0 u_sub.u_core.u_regfile.g_word\[3\].g_byte\[1\].u_lat/Q1
+ u_sub.u_core.u_regfile.g_word\[3\].g_byte\[1\].u_lat/Q2 u_sub.u_core.u_regfile.g_word\[3\].g_byte\[1\].u_lat/Q3
+ u_sub.u_core.u_regfile.g_word\[3\].g_byte\[1\].u_lat/Q4 u_sub.u_core.u_regfile.g_word\[3\].g_byte\[1\].u_lat/Q5
+ u_sub.u_core.u_regfile.g_word\[3\].g_byte\[1\].u_lat/Q6 u_sub.u_core.u_regfile.g_word\[3\].g_byte\[1\].u_lat/Q7
+ dlxtp8_x1
X_1740_ _1750_/B _1739_/Y VGND VGND VDPWR VDPWR _1740_/Y sky130_fd_sc_hd__nor2b_1
X_1671_ _1673_/A _1671_/B VGND VGND VDPWR VDPWR _2053_/D sky130_fd_sc_hd__nor2_1
XFILLER_38_201 VGND VGND VDPWR VDPWR sky130_fd_sc_hd__decap_3
XFILLER_53_248 VGND VGND VDPWR VDPWR sky130_fd_sc_hd__decap_3
XPHY_EDGE_ROW_38_2_2_Right_57 VGND VDPWR sky130_fd_sc_hd__tapvpwrvgnd_1
X_2223_ _2223_/D _2223_/GATE VGND VGND VDPWR VDPWR hold62/A sky130_fd_sc_hd__dlxtp_1
X_2154_ clkload8/A _2154_/D _2044_/A VGND VGND VDPWR VDPWR _2154_/Q sky130_fd_sc_hd__dfrtp_1
X_2085_ clkload8/A _2085_/D VGND VGND VDPWR VDPWR _2085_/Q sky130_fd_sc_hd__dfxtp_1
X_1105_ _1485_/A _1584_/A VGND VGND VDPWR VDPWR _1498_/B sky130_fd_sc_hd__nor2_1
XTAP_TAPCELL_ROW_63_276 VGND VDPWR sky130_fd_sc_hd__tapvpwrvgnd_1
X_1036_ _1282_/B _1117_/B VGND VGND VDPWR VDPWR _1120_/C sky130_fd_sc_hd__nor2_1
X_1938_ _1934_/Y _1937_/Y _1914_/Y VGND VGND VDPWR VDPWR _2119_/D sky130_fd_sc_hd__a21oi_1
X_1869_ _1869_/A _1869_/B VGND VGND VDPWR VDPWR _1869_/Y sky130_fd_sc_hd__nand2_1
XFILLER_67_27 VGND VGND VDPWR VDPWR sky130_fd_sc_hd__decap_3
XFILLER_67_38 VGND VGND VDPWR VDPWR sky130_fd_sc_hd__decap_3
XFILLER_44_248 VGND VGND VDPWR VDPWR sky130_fd_sc_hd__decap_3
XFILLER_44_259 VGND VGND VDPWR VDPWR sky130_fd_sc_hd__decap_3
XTAP_TAPCELL_ROW_77_346 VGND VDPWR sky130_fd_sc_hd__tapvpwrvgnd_1
XTAP_TAPCELL_ROW_60_257 VGND VDPWR sky130_fd_sc_hd__tapvpwrvgnd_1
Xclkbuf_1_1__f_u_sub.u_core.u_cg_wb_hi.gclk_o clkbuf_0_u_sub.u_core.u_cg_wb_hi.gclk_o/X
+ VGND VGND VDPWR VDPWR _2100_/CLK sky130_fd_sc_hd__clkbuf_2
Xhold149 _2086_/Q VGND VGND VDPWR VDPWR hold149/X sky130_fd_sc_hd__dlygate4sd3_1
X_1723_ _2052_/Q _1723_/B _1723_/C wire7/X VGND VGND VDPWR VDPWR _1724_/B sky130_fd_sc_hd__nand4_1
X_1654_ wire7/X _1881_/B VGND VGND VDPWR VDPWR _1655_/C sky130_fd_sc_hd__nand2_1
XFILLER_37_19 VGND VGND VDPWR VDPWR sky130_fd_sc_hd__fill_1
X_2206_ _2207_/CLK hold35/X VGND VGND VDPWR VDPWR hold27/A sky130_fd_sc_hd__dfxtp_1
X_1585_ _1586_/A wire85/X _1753_/C VGND VGND VDPWR VDPWR _1854_/B sky130_fd_sc_hd__nor3_1
XFILLER_34_270 VGND VGND VDPWR VDPWR sky130_fd_sc_hd__fill_2
X_1019_ _2043_/B _2155_/Q VGND VGND VDPWR VDPWR _1652_/S sky130_fd_sc_hd__and2_1
X_2137_ _2151_/CLK _2137_/D VGND VGND VDPWR VDPWR _2137_/Q sky130_fd_sc_hd__dfxtp_1
X_2068_ clkload4/A _2068_/D VGND VGND VDPWR VDPWR _2068_/Q sky130_fd_sc_hd__dfxtp_1
XTAP_TAPCELL_ROW_51_213 VGND VDPWR sky130_fd_sc_hd__tapvpwrvgnd_1
XFILLER_49_307 VGND VGND VDPWR VDPWR sky130_fd_sc_hd__fill_1
XTAP_TAPCELL_ROW_74_327 VGND VDPWR sky130_fd_sc_hd__tapvpwrvgnd_1
XFILLER_40_251 VGND VGND VDPWR VDPWR sky130_fd_sc_hd__fill_1
XFILLER_40_273 VGND VGND VDPWR VDPWR sky130_fd_sc_hd__decap_3
X_1370_ _1959_/A hold49/A _1368_/X _1369_/Y VGND VGND VDPWR VDPWR _1371_/B sky130_fd_sc_hd__o211ai_1
XFILLER_63_343 VGND VGND VDPWR VDPWR sky130_fd_sc_hd__fill_2
XPHY_EDGE_ROW_22_2_2_Right_41 VGND VDPWR sky130_fd_sc_hd__tapvpwrvgnd_1
Xclkbuf_1_0__f_u_sub.u_core.epc_gclk clkbuf_0_u_sub.u_core.epc_gclk/X VGND VGND VDPWR
+ VDPWR _2210_/CLK sky130_fd_sc_hd__clkbuf_2
X_1706_ _2064_/Q _1714_/B _1711_/C VGND VGND VDPWR VDPWR _1709_/A sky130_fd_sc_hd__a21oi_1
X_1637_ _1849_/A _1637_/B VGND VGND VDPWR VDPWR _1637_/Y sky130_fd_sc_hd__nor2_1
XFILLER_58_137 VGND VGND VDPWR VDPWR sky130_fd_sc_hd__fill_1
X_1568_ _1567_/B _1567_/C _1567_/D _1009_/Y VGND VGND VDPWR VDPWR _1570_/C sky130_fd_sc_hd__a31o_1
X_1499_ _1487_/Y _1499_/B VGND VGND VDPWR VDPWR _1499_/Y sky130_fd_sc_hd__nand2b_1
X_1422_ _1894_/A _1723_/C _1624_/B _2037_/A VGND VGND VDPWR VDPWR _1426_/B sky130_fd_sc_hd__or4_1
XFILLER_55_118 VGND VGND VDPWR VDPWR sky130_fd_sc_hd__decap_3
X_1353_ _2043_/B _2154_/Q VGND VGND VDPWR VDPWR _1524_/A sky130_fd_sc_hd__nand2_1
X_1284_ _1242_/B _1283_/X _1238_/Y VGND VGND VDPWR VDPWR _1285_/C sky130_fd_sc_hd__a21oi_1
XFILLER_48_192 VGND VGND VDPWR VDPWR sky130_fd_sc_hd__decap_3
Xclkload8 clkload8/A VGND VGND VDPWR VDPWR clkload8/Y sky130_fd_sc_hd__inv_8
XFILLER_54_151 VGND VGND VDPWR VDPWR sky130_fd_sc_hd__fill_2
XFILLER_10_210 VGND VGND VDPWR VDPWR sky130_fd_sc_hd__fill_2
XFILLER_49_94 VGND VGND VDPWR VDPWR sky130_fd_sc_hd__fill_1
Xu_sub.u_core.u_regfile.g_nibsel\[2\].g_nib\[0\].u_lo u_sub.u_core.u_regfile.g_word\[2\].g_byte\[0\].u_lat/Q0
+ u_sub.u_core.u_regfile.g_word\[2\].g_byte\[0\].u_lat/Q4 u_sub.u_core.u_regfile.g_word\[2\].g_byte\[1\].u_lat/Q0
+ u_sub.u_core.u_regfile.g_word\[2\].g_byte\[1\].u_lat/Q4 max_cap4/X max_cap2/X VGND
+ VGND VDPWR VDPWR u_sub.u_core.u_regfile.g_nibsel\[2\].g_nib\[0\].u_lo/X tg_mux4_x1
X_1971_ _1971_/A _1971_/B VGND VGND VDPWR VDPWR _2125_/D sky130_fd_sc_hd__nor2_1
X_1405_ _1410_/A _1753_/B _1404_/A _1756_/B _1584_/C VGND VGND VDPWR VDPWR _1405_/Y
+ sky130_fd_sc_hd__a2111oi_1
X_1336_ _1336_/A _1336_/B VGND VGND VDPWR VDPWR _1795_/A sky130_fd_sc_hd__xnor2_1
X_1267_ _1652_/S _1588_/B VGND VGND VDPWR VDPWR _1267_/Y sky130_fd_sc_hd__nand2_1
X_1198_ _1199_/A _1199_/B _1331_/A VGND VGND VDPWR VDPWR _1202_/B sky130_fd_sc_hd__o21a_1
XTAP_TAPCELL_ROW_46_190 VGND VDPWR sky130_fd_sc_hd__tapvpwrvgnd_1
XFILLER_32_7 VGND VGND VDPWR VDPWR sky130_fd_sc_hd__decap_3
X_2170_ _2175_/CLK hold63/X hold20/X VGND VGND VDPWR VDPWR hold65/A sky130_fd_sc_hd__dfrtp_1
X_1121_ _1117_/C _1121_/B _1142_/A _1121_/D VGND VGND VDPWR VDPWR _1123_/D sky130_fd_sc_hd__nand4b_1
X_1052_ _1052_/A _1130_/B VGND VGND VDPWR VDPWR _1167_/B sky130_fd_sc_hd__nand2_1
X_1954_ _2125_/Q _1806_/A _1939_/B _1953_/Y VGND VGND VDPWR VDPWR _1955_/B sky130_fd_sc_hd__a31oi_1
X_1885_ _2109_/Q _1881_/X _1729_/A VGND VGND VDPWR VDPWR _1886_/B sky130_fd_sc_hd__o21ai_1
XFILLER_71_205 VGND VGND VDPWR VDPWR sky130_fd_sc_hd__fill_1
XTAP_TAPCELL_ROW_20_2_2_145 VGND VDPWR sky130_fd_sc_hd__tapvpwrvgnd_1
X_1319_ _1117_/C _1278_/B _1841_/S VGND VGND VDPWR VDPWR _1319_/Y sky130_fd_sc_hd__a21oi_1
Xdelaybuf_2_clk delaybuf_2_clk/A VGND VGND VDPWR VDPWR u_fpga/clk sky130_fd_sc_hd__clkbuf_2
XFILLER_62_205 VGND VGND VDPWR VDPWR sky130_fd_sc_hd__decap_3
XPHY_EDGE_ROW_19_2_2_Right_38 VGND VDPWR sky130_fd_sc_hd__tapvpwrvgnd_1
X_1670_ _2053_/Q _1672_/B VGND VGND VDPWR VDPWR _1671_/B sky130_fd_sc_hd__nor2_1
X_2222_ _2222_/D _2222_/GATE VGND VGND VDPWR VDPWR _2222_/Q sky130_fd_sc_hd__dlxtp_1
X_1035_ _1124_/C _1139_/A _1046_/C _1035_/D VGND VGND VDPWR VDPWR _1123_/A sky130_fd_sc_hd__nand4_1
X_2153_ clkload7/A _2153_/D _2044_/A VGND VGND VDPWR VDPWR _2153_/Q sky130_fd_sc_hd__dfrtp_1
X_2084_ clkload9/A _2084_/D VGND VGND VDPWR VDPWR _2084_/Q sky130_fd_sc_hd__dfxtp_1
X_1104_ _1104_/A _1104_/B _1124_/C VGND VGND VDPWR VDPWR _1584_/A sky130_fd_sc_hd__or3_1
X_1937_ wire70/A _1936_/Y _1928_/Y VGND VGND VDPWR VDPWR _1937_/Y sky130_fd_sc_hd__a21oi_1
X_1868_ _2051_/Q _1632_/Y _1881_/D _2109_/Q VGND VGND VDPWR VDPWR _1869_/B sky130_fd_sc_hd__a22oi_1
X_1799_ _2092_/Q wire96/X VGND VGND VDPWR VDPWR _1799_/Y sky130_fd_sc_hd__nor2_1
XFILLER_44_205 VGND VGND VDPWR VDPWR sky130_fd_sc_hd__fill_1
XFILLER_44_227 VGND VGND VDPWR VDPWR sky130_fd_sc_hd__decap_3
XFILLER_32_31 VGND VGND VDPWR VDPWR sky130_fd_sc_hd__decap_3
XFILLER_32_53 VGND VGND VDPWR VDPWR sky130_fd_sc_hd__decap_3
XFILLER_32_75 VGND VGND VDPWR VDPWR sky130_fd_sc_hd__decap_3
XFILLER_35_216 VGND VGND VDPWR VDPWR sky130_fd_sc_hd__fill_2
XFILLER_57_83 VGND VGND VDPWR VDPWR sky130_fd_sc_hd__fill_1
XFILLER_50_208 VGND VGND VDPWR VDPWR sky130_fd_sc_hd__fill_2
XTAP_TAPCELL_ROW_60_258 VGND VDPWR sky130_fd_sc_hd__tapvpwrvgnd_1
XPHY_EDGE_ROW_44_Left_103 VGND VDPWR sky130_fd_sc_hd__tapvpwrvgnd_1
X_1722_ _1691_/B _1721_/Y _1729_/A VGND VGND VDPWR VDPWR _2068_/D sky130_fd_sc_hd__a21boi_1
X_1653_ _1729_/A wire86/X _1653_/C VGND VGND VDPWR VDPWR _1673_/A sky130_fd_sc_hd__nand3_1
X_1584_ _1584_/A _1584_/B _1584_/C VGND VGND VDPWR VDPWR _1753_/C sky130_fd_sc_hd__nor3_1
XPHY_EDGE_ROW_53_Left_112 VGND VDPWR sky130_fd_sc_hd__tapvpwrvgnd_1
X_2205_ _2210_/CLK hold30/X VGND VGND VDPWR VDPWR hold32/A sky130_fd_sc_hd__dfxtp_1
XTAP_TAPCELL_ROW_51_214 VGND VDPWR sky130_fd_sc_hd__tapvpwrvgnd_1
X_1018_ _2179_/Q _2163_/Q _1959_/A VGND VGND VDPWR VDPWR _1676_/B sky130_fd_sc_hd__mux2_1
X_2136_ _2151_/CLK _2136_/D VGND VGND VDPWR VDPWR _2136_/Q sky130_fd_sc_hd__dfxtp_1
X_2067_ clkload6/A _2067_/D VGND VGND VDPWR VDPWR _2067_/Q sky130_fd_sc_hd__dfxtp_1
XPHY_EDGE_ROW_62_Left_121 VGND VDPWR sky130_fd_sc_hd__tapvpwrvgnd_1
Xu_sub.u_core.u_regfile.g_ir\[1\].u_lat _2093_/Q _2094_/Q wire116/X _2096_/Q wire112/X
+ max_cap110/X _2099_/Q max_cap107/X u_sub.u_core.u_regfile.g_ir\[1\].u_lat/GATE VGND
+ VDPWR _1134_/A _1033_/A _1539_/A _1033_/C wire137/A wire135/A wire134/A _1034_/A
+ dlxtp8_x1
XPHY_EDGE_ROW_71_Left_130 VGND VDPWR sky130_fd_sc_hd__tapvpwrvgnd_1
XTAP_TAPCELL_ROW_74_328 VGND VDPWR sky130_fd_sc_hd__tapvpwrvgnd_1
XFILLER_48_341 VGND VGND VDPWR VDPWR sky130_fd_sc_hd__decap_3
XFILLER_4_197 VGND VGND VDPWR VDPWR sky130_fd_sc_hd__decap_3
XFILLER_68_82 VGND VGND VDPWR VDPWR sky130_fd_sc_hd__fill_1
Xu_sub.u_core.u_regfile.g_nibsel\[3\].g_nib\[2\].u_m2 u_sub.u_core.u_regfile.g_nibsel\[3\].g_nib\[2\].u_lo/X
+ u_sub.u_core.u_regfile.g_nibsel\[3\].g_nib\[2\].u_hi/X max_cap1/X VGND VGND VDPWR
+ VDPWR u_sub.u_core.u_regfile.g_port\[2\].u_b/A2 sky130_fd_sc_hd__mux2_1
XFILLER_23_208 VGND VGND VDPWR VDPWR sky130_fd_sc_hd__decap_3
X_1705_ _1705_/A _1711_/C _2044_/A VGND VGND VDPWR VDPWR _2063_/D sky130_fd_sc_hd__nor3b_1
Xu_sub.u_core.u_regfile.g_word\[2\].g_byte\[0\].u_cg.u_icg clkbuf_leaf_0_clk/X _1535_/Y
+ VGND VGND VDPWR VDPWR u_sub.u_core.u_regfile.g_word\[2\].g_byte\[0\].u_lat/GATE
+ sky130_fd_sc_hd__dlclkp_1
X_1636_ _2075_/Q wire7/X _1635_/X _1630_/X _1429_/D VGND VGND VDPWR VDPWR _1637_/B
+ sky130_fd_sc_hd__a32oi_1
X_1567_ _2090_/Q _1567_/B _1567_/C _1567_/D VGND VGND VDPWR VDPWR _1570_/B sky130_fd_sc_hd__nand4_1
XFILLER_54_344 VGND VGND VDPWR VDPWR sky130_fd_sc_hd__fill_1
X_2119_ clkload9/A _2119_/D VGND VGND VDPWR VDPWR uio_out[0] sky130_fd_sc_hd__dfxtp_1
X_1498_ _1498_/A _1498_/B _1498_/C VGND VGND VDPWR VDPWR _1499_/B sky130_fd_sc_hd__nor3_1
XFILLER_57_171 VGND VGND VDPWR VDPWR sky130_fd_sc_hd__decap_3
XFILLER_54_95 VGND VGND VDPWR VDPWR sky130_fd_sc_hd__fill_2
XFILLER_70_61 VGND VGND VDPWR VDPWR sky130_fd_sc_hd__decap_3
XFILLER_70_72 VGND VGND VDPWR VDPWR sky130_fd_sc_hd__decap_3
XFILLER_9_201 VGND VGND VDPWR VDPWR sky130_fd_sc_hd__fill_1
XFILLER_9_212 VGND VGND VDPWR VDPWR sky130_fd_sc_hd__fill_1
X_1421_ _1421_/A _1421_/B VGND VGND VDPWR VDPWR _1421_/Y sky130_fd_sc_hd__nand2_1
XFILLER_36_344 VGND VGND VDPWR VDPWR sky130_fd_sc_hd__fill_1
XFILLER_48_182 VGND VGND VDPWR VDPWR sky130_fd_sc_hd__fill_1
XFILLER_63_130 VGND VGND VDPWR VDPWR sky130_fd_sc_hd__fill_2
X_1352_ _2043_/B _2154_/Q VGND VGND VDPWR VDPWR _1352_/X sky130_fd_sc_hd__and2_1
X_1283_ _1841_/S _1141_/B _1242_/A _1282_/Y VGND VGND VDPWR VDPWR _1283_/X sky130_fd_sc_hd__a211o_1
XFILLER_63_152 VGND VGND VDPWR VDPWR sky130_fd_sc_hd__fill_1
Xclkload9 clkload9/A VGND VGND VDPWR VDPWR clkload9/Y sky130_fd_sc_hd__clkinvlp_4
X_1619_ uio_in[0] wire97/X VGND VGND VDPWR VDPWR _1619_/Y sky130_fd_sc_hd__nor2_1
XFILLER_46_108 VGND VGND VDPWR VDPWR sky130_fd_sc_hd__fill_2
XFILLER_6_204 VGND VGND VDPWR VDPWR sky130_fd_sc_hd__fill_1
XFILLER_40_86 VGND VGND VDPWR VDPWR sky130_fd_sc_hd__decap_3
XFILLER_45_130 VGND VGND VDPWR VDPWR sky130_fd_sc_hd__decap_3
XFILLER_60_144 VGND VGND VDPWR VDPWR sky130_fd_sc_hd__decap_3
XFILLER_65_61 VGND VGND VDPWR VDPWR sky130_fd_sc_hd__decap_3
X_1970_ _2118_/D _1970_/B VGND VGND VDPWR VDPWR _1971_/B sky130_fd_sc_hd__nor2_1
XFILLER_39_1 VGND VGND VDPWR VDPWR sky130_fd_sc_hd__decap_3
X_1404_ _1404_/A _1584_/C VGND VGND VDPWR VDPWR _1404_/Y sky130_fd_sc_hd__nor2_1
X_1335_ _1299_/A _1299_/B _1296_/Y VGND VGND VDPWR VDPWR _1336_/B sky130_fd_sc_hd__o21ai_1
XFILLER_36_163 VGND VGND VDPWR VDPWR sky130_fd_sc_hd__fill_2
X_1266_ _1225_/Y _1265_/Y _1652_/S VGND VGND VDPWR VDPWR _2176_/D sky130_fd_sc_hd__a21oi_1
X_1197_ _1757_/C _1196_/Y _1215_/C VGND VGND VDPWR VDPWR _1331_/A sky130_fd_sc_hd__o21ai_1
XFILLER_51_144 VGND VGND VDPWR VDPWR sky130_fd_sc_hd__fill_2
XFILLER_51_177 VGND VGND VDPWR VDPWR sky130_fd_sc_hd__fill_2
XFILLER_51_188 VGND VGND VDPWR VDPWR sky130_fd_sc_hd__decap_3
XTAP_TAPCELL_ROW_46_191 VGND VDPWR sky130_fd_sc_hd__tapvpwrvgnd_1
XFILLER_3_229 VGND VGND VDPWR VDPWR sky130_fd_sc_hd__decap_3
XFILLER_59_233 VGND VGND VDPWR VDPWR sky130_fd_sc_hd__decap_3
XFILLER_65_203 VGND VGND VDPWR VDPWR sky130_fd_sc_hd__decap_3
X_1120_ _1141_/B _1167_/A _1120_/C _1120_/D VGND VGND VDPWR VDPWR _1123_/C sky130_fd_sc_hd__nand4_1
X_1051_ _1485_/A _1129_/A VGND VGND VDPWR VDPWR _1053_/B sky130_fd_sc_hd__nor2_1
XTAP_TAPCELL_ROW_43_172 VGND VDPWR sky130_fd_sc_hd__tapvpwrvgnd_1
X_1953_ _1445_/Y _1970_/B _1952_/Y _1941_/A VGND VGND VDPWR VDPWR _1953_/Y sky130_fd_sc_hd__o22ai_1
X_1884_ _2213_/D _1890_/B VGND VGND VDPWR VDPWR _1886_/A sky130_fd_sc_hd__nor2_1
Xclkbuf_1_1__f_u_sub.u_core.u_cg_wb_lo.gclk_o clkbuf_0_u_sub.u_core.u_cg_wb_lo.gclk_o/X
+ VGND VGND VDPWR VDPWR _2095_/CLK sky130_fd_sc_hd__clkbuf_2
XFILLER_56_203 VGND VGND VDPWR VDPWR sky130_fd_sc_hd__fill_1
X_1318_ _1326_/A _1316_/Y _1317_/Y VGND VGND VDPWR VDPWR _1321_/A sky130_fd_sc_hd__a21oi_1
XFILLER_71_217 VGND VGND VDPWR VDPWR sky130_fd_sc_hd__decap_3
XPHY_EDGE_ROW_18_2_2_Left_7 VGND VDPWR sky130_fd_sc_hd__tapvpwrvgnd_1
X_1249_ _1278_/B _1249_/B VGND VGND VDPWR VDPWR _1250_/C sky130_fd_sc_hd__nor2_1
XFILLER_47_225 VGND VGND VDPWR VDPWR sky130_fd_sc_hd__decap_3
XFILLER_47_236 VGND VGND VDPWR VDPWR sky130_fd_sc_hd__fill_2
XTAP_TAPCELL_ROW_57_242 VGND VDPWR sky130_fd_sc_hd__tapvpwrvgnd_1
Xu_sub.u_core.u_regfile.g_word\[4\].g_byte\[3\].u_cg.u_icg clkbuf_leaf_2_clk/X _1548_/Y
+ VGND VGND VDPWR VDPWR u_sub.u_core.u_regfile.g_word\[4\].g_byte\[3\].u_lat/GATE
+ sky130_fd_sc_hd__dlclkp_1
XFILLER_15_188 VGND VGND VDPWR VDPWR sky130_fd_sc_hd__fill_2
XFILLER_70_250 VGND VGND VDPWR VDPWR sky130_fd_sc_hd__fill_2
X_2221_ _2221_/D _2223_/GATE VGND VGND VDPWR VDPWR _2221_/Q sky130_fd_sc_hd__dlxtp_1
X_2152_ clkload7/A _2152_/D _2044_/A VGND VGND VDPWR VDPWR _2152_/Q sky130_fd_sc_hd__dfstp_2
XFILLER_53_239 VGND VGND VDPWR VDPWR sky130_fd_sc_hd__fill_1
X_1034_ _1034_/A _1512_/B _1513_/A VGND VGND VDPWR VDPWR _1035_/D sky130_fd_sc_hd__nor3_1
X_2083_ clkload9/A _2083_/D VGND VGND VDPWR VDPWR _2083_/Q sky130_fd_sc_hd__dfxtp_1
X_1103_ _1103_/A _1124_/C VGND VGND VDPWR VDPWR _1103_/Y sky130_fd_sc_hd__nor2_1
X_1936_ _1936_/A _1936_/B VGND VGND VDPWR VDPWR _1936_/Y sky130_fd_sc_hd__nor2_1
X_1867_ _2103_/Q _1875_/A _1866_/Y _1729_/A VGND VGND VDPWR VDPWR _2103_/D sky130_fd_sc_hd__o211a_1
XTAP_TAPCELL_ROW_24_2_2_147 VGND VDPWR sky130_fd_sc_hd__tapvpwrvgnd_1
X_1798_ _1798_/A _1798_/B VGND VGND VDPWR VDPWR _1798_/X sky130_fd_sc_hd__xor2_1
XFILLER_29_203 VGND VGND VDPWR VDPWR sky130_fd_sc_hd__fill_2
XFILLER_29_225 VGND VGND VDPWR VDPWR sky130_fd_sc_hd__decap_3
XFILLER_32_10 VGND VGND VDPWR VDPWR sky130_fd_sc_hd__decap_3
XFILLER_44_239 VGND VGND VDPWR VDPWR sky130_fd_sc_hd__decap_3
XFILLER_52_250 VGND VGND VDPWR VDPWR sky130_fd_sc_hd__decap_3
XFILLER_20_191 VGND VGND VDPWR VDPWR sky130_fd_sc_hd__fill_2
XFILLER_32_65 VGND VGND VDPWR VDPWR sky130_fd_sc_hd__decap_3
XPHY_EDGE_ROW_40_2_2_Right_59 VGND VDPWR sky130_fd_sc_hd__tapvpwrvgnd_1
XFILLER_11_191 VGND VGND VDPWR VDPWR sky130_fd_sc_hd__fill_1
XTAP_TAPCELL_ROW_60_259 VGND VDPWR sky130_fd_sc_hd__tapvpwrvgnd_1
X_1721_ _2068_/Q _1721_/B VGND VGND VDPWR VDPWR _1721_/Y sky130_fd_sc_hd__nand2_1
X_1652_ _2198_/Q _2166_/Q _1652_/S VGND VGND VDPWR VDPWR _2210_/D sky130_fd_sc_hd__mux2_1
X_1583_ _1771_/A _1790_/C _1575_/Y VGND VGND VDPWR VDPWR _1583_/Y sky130_fd_sc_hd__o21ai_1
X_2204_ _2210_/CLK hold31/X VGND VGND VDPWR VDPWR hold33/A sky130_fd_sc_hd__dfxtp_1
X_2135_ _2151_/CLK _2135_/D VGND VGND VDPWR VDPWR _2135_/Q sky130_fd_sc_hd__dfxtp_1
XTAP_TAPCELL_ROW_51_215 VGND VDPWR sky130_fd_sc_hd__tapvpwrvgnd_1
X_1017_ hold47/X VGND VGND VDPWR VDPWR _1017_/Y sky130_fd_sc_hd__inv_1
Xu_sub.u_core.u_regfile.g_nibsel\[4\].g_nib\[0\].u_m2 u_sub.u_core.u_regfile.g_nibsel\[4\].g_nib\[0\].u_lo/X
+ u_sub.u_core.u_regfile.g_nibsel\[4\].g_nib\[0\].u_hi/X max_cap1/X VGND VGND VDPWR
+ VDPWR u_sub.u_core.u_regfile.g_port\[0\].u_b/A3 sky130_fd_sc_hd__mux2_1
X_2066_ _2151_/CLK _2066_/D VGND VGND VDPWR VDPWR _2066_/Q sky130_fd_sc_hd__dfxtp_1
X_1919_ _1936_/A _1930_/A VGND VGND VDPWR VDPWR _1963_/A sky130_fd_sc_hd__nand2_1
XTAP_TAPCELL_ROW_74_329 VGND VDPWR sky130_fd_sc_hd__tapvpwrvgnd_1
XFILLER_43_86 VGND VGND VDPWR VDPWR sky130_fd_sc_hd__decap_3
XFILLER_68_50 VGND VGND VDPWR VDPWR sky130_fd_sc_hd__decap_3
XFILLER_69_1 VGND VGND VDPWR VDPWR sky130_fd_sc_hd__decap_3
X_1704_ _2063_/Q _1704_/B VGND VGND VDPWR VDPWR _1711_/C sky130_fd_sc_hd__and2_1
X_1635_ _2103_/Q _1881_/B _1787_/C _2067_/Q VGND VGND VDPWR VDPWR _1635_/X sky130_fd_sc_hd__a22o_1
X_1566_ _1566_/A _1771_/A VGND VGND VDPWR VDPWR _1566_/Y sky130_fd_sc_hd__nand2_1
X_1497_ _1647_/B _1483_/Y _1775_/B VGND VGND VDPWR VDPWR _1497_/Y sky130_fd_sc_hd__o21ai_1
X_2118_ clkload9/A _2118_/D VGND VGND VDPWR VDPWR hold23/A sky130_fd_sc_hd__dfxtp_1
X_2049_ clkload6/A _2049_/D VGND VGND VDPWR VDPWR hold46/A sky130_fd_sc_hd__dfxtp_1
XFILLER_49_106 VGND VGND VDPWR VDPWR sky130_fd_sc_hd__decap_3
XFILLER_64_109 VGND VGND VDPWR VDPWR sky130_fd_sc_hd__decap_3
XFILLER_45_323 VGND VGND VDPWR VDPWR sky130_fd_sc_hd__fill_1
XFILLER_57_183 VGND VGND VDPWR VDPWR sky130_fd_sc_hd__decap_3
XTAP_TAPCELL_ROW_70_310 VGND VDPWR sky130_fd_sc_hd__tapvpwrvgnd_1
XFILLER_70_40 VGND VGND VDPWR VDPWR sky130_fd_sc_hd__decap_3
XFILLER_9_235 VGND VGND VDPWR VDPWR sky130_fd_sc_hd__fill_1
X_1420_ _2043_/B _2157_/Q wire95/X VGND VGND VDPWR VDPWR _1421_/B sky130_fd_sc_hd__nand3_1
X_1351_ _1153_/D _1039_/Y _1430_/B VGND VGND VDPWR VDPWR wire93/A sky130_fd_sc_hd__a21oi_1
XFILLER_36_323 VGND VGND VDPWR VDPWR sky130_fd_sc_hd__fill_2
XFILLER_48_150 VGND VGND VDPWR VDPWR sky130_fd_sc_hd__decap_3
XFILLER_63_164 VGND VGND VDPWR VDPWR sky130_fd_sc_hd__decap_3
X_1282_ _1841_/S _1282_/B VGND VGND VDPWR VDPWR _1282_/Y sky130_fd_sc_hd__nor2_1
X_1618_ _1483_/B _1616_/Y _2151_/Q VGND VGND VDPWR VDPWR _1852_/A sky130_fd_sc_hd__a21oi_1
X_1549_ _1549_/A wire73/X _1549_/C VGND VGND VDPWR VDPWR _1553_/B sky130_fd_sc_hd__nand3_1
XFILLER_54_120 VGND VGND VDPWR VDPWR sky130_fd_sc_hd__decap_3
XFILLER_45_142 VGND VGND VDPWR VDPWR sky130_fd_sc_hd__decap_3
XFILLER_60_123 VGND VGND VDPWR VDPWR sky130_fd_sc_hd__fill_2
XFILLER_60_189 VGND VGND VDPWR VDPWR sky130_fd_sc_hd__decap_3
Xdelaybuf_21_clk clk VGND VGND VDPWR VDPWR delaybuf_22_clk/A sky130_fd_sc_hd__clkbuf_2
X_1403_ _1403_/A wire73/X VGND VGND VDPWR VDPWR _1403_/X sky130_fd_sc_hd__or2_1
X_1334_ _1339_/A _1334_/B VGND VGND VDPWR VDPWR _1336_/A sky130_fd_sc_hd__xnor2_1
X_1265_ _2196_/Q _1471_/B _1264_/Y VGND VGND VDPWR VDPWR _1265_/Y sky130_fd_sc_hd__o21ai_1
XFILLER_51_134 VGND VGND VDPWR VDPWR sky130_fd_sc_hd__fill_2
XTAP_TAPCELL_ROW_32_2_2_151 VGND VDPWR sky130_fd_sc_hd__tapvpwrvgnd_1
X_1196_ _1213_/A _1757_/B VGND VGND VDPWR VDPWR _1196_/Y sky130_fd_sc_hd__nand2_1
XPHY_EDGE_ROW_34_2_2_Right_53 VGND VDPWR sky130_fd_sc_hd__tapvpwrvgnd_1
XFILLER_59_201 VGND VGND VDPWR VDPWR sky130_fd_sc_hd__fill_2
Xu_sub.u_core.u_regfile.g_word\[2\].g_byte\[0\].u_lat max_cap120/X max_cap118/X wire116/X
+ max_cap114/X wire112/X max_cap110/X max_cap108/X max_cap106/X u_sub.u_core.u_regfile.g_word\[2\].g_byte\[0\].u_lat/GATE
+ VGND VDPWR u_sub.u_core.u_regfile.g_word\[2\].g_byte\[0\].u_lat/Q0 u_sub.u_core.u_regfile.g_word\[2\].g_byte\[0\].u_lat/Q1
+ u_sub.u_core.u_regfile.g_word\[2\].g_byte\[0\].u_lat/Q2 u_sub.u_core.u_regfile.g_word\[2\].g_byte\[0\].u_lat/Q3
+ u_sub.u_core.u_regfile.g_word\[2\].g_byte\[0\].u_lat/Q4 u_sub.u_core.u_regfile.g_word\[2\].g_byte\[0\].u_lat/Q5
+ u_sub.u_core.u_regfile.g_word\[2\].g_byte\[0\].u_lat/Q6 u_sub.u_core.u_regfile.g_word\[2\].g_byte\[0\].u_lat/Q7
+ dlxtp8_x1
XFILLER_59_223 VGND VGND VDPWR VDPWR sky130_fd_sc_hd__fill_2
Xdelaybuf_12_clk delaybuf_12_clk/A VGND VGND VDPWR VDPWR delaybuf_13_clk/A sky130_fd_sc_hd__clkbuf_2
XFILLER_27_197 VGND VGND VDPWR VDPWR sky130_fd_sc_hd__decap_3
XFILLER_35_10 VGND VGND VDPWR VDPWR sky130_fd_sc_hd__decap_3
XFILLER_42_134 VGND VGND VDPWR VDPWR sky130_fd_sc_hd__fill_2
XFILLER_33_112 VGND VGND VDPWR VDPWR sky130_fd_sc_hd__fill_1
XFILLER_33_134 VGND VGND VDPWR VDPWR sky130_fd_sc_hd__fill_2
X_1050_ _1485_/A _1102_/C VGND VGND VDPWR VDPWR _1169_/A sky130_fd_sc_hd__nor2_1
XPHY_EDGE_ROW_31_2_2_Left_20 VGND VDPWR sky130_fd_sc_hd__tapvpwrvgnd_1
XTAP_TAPCELL_ROW_43_173 VGND VDPWR sky130_fd_sc_hd__tapvpwrvgnd_1
X_1952_ _2124_/Q _1368_/X _1951_/Y VGND VGND VDPWR VDPWR _1952_/Y sky130_fd_sc_hd__o21ai_1
X_1883_ _1883_/A _1883_/B VGND VGND VDPWR VDPWR _2108_/D sky130_fd_sc_hd__nor2_1
XFILLER_51_1 VGND VGND VDPWR VDPWR sky130_fd_sc_hd__fill_1
X_1317_ _1348_/A _1172_/Y _1235_/Y _1242_/Y VGND VGND VDPWR VDPWR _1317_/Y sky130_fd_sc_hd__o211ai_1
X_1248_ _1117_/B _1021_/Y _1324_/A _1142_/A VGND VGND VDPWR VDPWR _1249_/B sky130_fd_sc_hd__a22oi_1
XTAP_TAPCELL_ROW_66_287 VGND VDPWR sky130_fd_sc_hd__tapvpwrvgnd_1
X_1179_ _1841_/S _1179_/B VGND VGND VDPWR VDPWR _1179_/X sky130_fd_sc_hd__or2_1
XFILLER_46_86 VGND VGND VDPWR VDPWR sky130_fd_sc_hd__fill_2
XFILLER_47_259 VGND VGND VDPWR VDPWR sky130_fd_sc_hd__decap_3
XTAP_TAPCELL_ROW_57_243 VGND VDPWR sky130_fd_sc_hd__tapvpwrvgnd_1
Xu_sub.u_core.u_regfile.g_nibsel\[4\].g_nib\[2\].u_hi u_sub.u_core.u_regfile.g_word\[4\].g_byte\[2\].u_lat/Q2
+ u_sub.u_core.u_regfile.g_word\[4\].g_byte\[2\].u_lat/Q6 u_sub.u_core.u_regfile.g_word\[4\].g_byte\[3\].u_lat/Q2
+ u_sub.u_core.u_regfile.g_word\[4\].g_byte\[3\].u_lat/Q6 max_cap5/X max_cap3/X VGND
+ VGND VDPWR VDPWR u_sub.u_core.u_regfile.g_nibsel\[4\].g_nib\[2\].u_hi/X tg_mux4_x1
Xmax_cap98 _1723_/B VGND VGND VDPWR VDPWR _1624_/A sky130_fd_sc_hd__buf_4
X_2220_ _2220_/D _2222_/GATE VGND VGND VDPWR VDPWR _2220_/Q sky130_fd_sc_hd__dlxtp_1
X_2151_ _2151_/CLK _2151_/D _2044_/A VGND VGND VDPWR VDPWR _2151_/Q sky130_fd_sc_hd__dfrtp_1
X_2082_ clkload8/A _2082_/D VGND VGND VDPWR VDPWR _2082_/Q sky130_fd_sc_hd__dfxtp_1
X_1102_ _1124_/C _1485_/A _1102_/C VGND VGND VDPWR VDPWR _1567_/C sky130_fd_sc_hd__or3_1
XFILLER_53_207 VGND VGND VDPWR VDPWR sky130_fd_sc_hd__decap_3
X_1033_ _1033_/A _1134_/A _1033_/C _1539_/A VGND VGND VDPWR VDPWR _1513_/A sky130_fd_sc_hd__or4_1
XPHY_EDGE_ROW_32_2_2_Left_21 VGND VDPWR sky130_fd_sc_hd__tapvpwrvgnd_1
X_1935_ _2126_/Q _2125_/Q _2124_/Q _2127_/Q VGND VGND VDPWR VDPWR _1935_/Y sky130_fd_sc_hd__a31oi_1
X_1866_ _1875_/A _1866_/B VGND VGND VDPWR VDPWR _1866_/Y sky130_fd_sc_hd__nand2_1
X_1797_ _1616_/A _1759_/X _1760_/Y _1796_/Y VGND VGND VDPWR VDPWR _1798_/B sky130_fd_sc_hd__o31ai_1
XFILLER_44_218 VGND VGND VDPWR VDPWR sky130_fd_sc_hd__decap_3
XFILLER_32_22 VGND VGND VDPWR VDPWR sky130_fd_sc_hd__decap_3
XFILLER_32_44 VGND VGND VDPWR VDPWR sky130_fd_sc_hd__decap_3
X_1720_ _1720_/A _1720_/B VGND VGND VDPWR VDPWR _1721_/B sky130_fd_sc_hd__or2_1
X_1651_ _2197_/Q _2165_/Q _1652_/S VGND VGND VDPWR VDPWR _2209_/D sky130_fd_sc_hd__mux2_1
X_1582_ _1827_/A _1582_/B VGND VGND VDPWR VDPWR _1790_/C sky130_fd_sc_hd__xnor2_1
XTAP_TAPCELL_ROW_28_2_2_149 VGND VDPWR sky130_fd_sc_hd__tapvpwrvgnd_1
X_2203_ _2207_/CLK hold26/X VGND VGND VDPWR VDPWR hold34/A sky130_fd_sc_hd__dfxtp_1
X_2134_ _2151_/CLK _2134_/D VGND VGND VDPWR VDPWR _2134_/Q sky130_fd_sc_hd__dfxtp_1
X_2065_ _2151_/CLK _2065_/D VGND VGND VDPWR VDPWR _2065_/Q sky130_fd_sc_hd__dfxtp_1
XTAP_TAPCELL_ROW_51_216 VGND VDPWR sky130_fd_sc_hd__tapvpwrvgnd_1
X_1016_ hold64/X VGND VGND VDPWR VDPWR _1016_/Y sky130_fd_sc_hd__inv_1
XPHY_EDGE_ROW_33_2_2_Left_22 VGND VDPWR sky130_fd_sc_hd__tapvpwrvgnd_1
X_1918_ _2125_/Q _2124_/Q _1932_/B VGND VGND VDPWR VDPWR _1970_/B sky130_fd_sc_hd__a21oi_1
X_1849_ _1849_/A _1849_/B VGND VGND VDPWR VDPWR _1849_/Y sky130_fd_sc_hd__nor2_1
XFILLER_40_276 VGND VGND VDPWR VDPWR sky130_fd_sc_hd__decap_3
XFILLER_4_188 VGND VGND VDPWR VDPWR sky130_fd_sc_hd__decap_3
X_1703_ _2063_/Q _1714_/B _1704_/B VGND VGND VDPWR VDPWR _1705_/A sky130_fd_sc_hd__a21oi_1
X_1634_ _1881_/B _1691_/A VGND VGND VDPWR VDPWR _1787_/C sky130_fd_sc_hd__nor2_1
X_1565_ _1561_/Y _1770_/B _1790_/A VGND VGND VDPWR VDPWR wire83/A sky130_fd_sc_hd__o21ai_2
X_1496_ _2150_/Q _2156_/Q VGND VGND VDPWR VDPWR _1775_/B sky130_fd_sc_hd__nand2_1
X_2117_ _2160_/CLK _2117_/D VGND VGND VDPWR VDPWR _2117_/Q sky130_fd_sc_hd__dfxtp_1
X_2048_ clkload4/A _2048_/D VGND VGND VDPWR VDPWR hold37/A sky130_fd_sc_hd__dfxtp_1
XFILLER_22_232 VGND VGND VDPWR VDPWR sky130_fd_sc_hd__decap_3
XPHY_EDGE_ROW_34_2_2_Left_23 VGND VDPWR sky130_fd_sc_hd__tapvpwrvgnd_1
Xu_sub.u_core.u_regfile.g_nibsel\[1\].g_nib\[1\].u_m2 u_sub.u_core.u_regfile.g_nibsel\[1\].g_nib\[1\].u_lo/X
+ u_sub.u_core.u_regfile.g_nibsel\[1\].g_nib\[1\].u_hi/X _1583_/Y VGND VGND VDPWR
+ VDPWR u_sub.u_core.u_regfile.g_port\[1\].u_b/A0 sky130_fd_sc_hd__mux2_1
XFILLER_45_302 VGND VGND VDPWR VDPWR sky130_fd_sc_hd__decap_3
XFILLER_45_313 VGND VGND VDPWR VDPWR sky130_fd_sc_hd__fill_1
XFILLER_13_210 VGND VGND VDPWR VDPWR sky130_fd_sc_hd__fill_1
XFILLER_54_86 VGND VGND VDPWR VDPWR sky130_fd_sc_hd__decap_3
XPHY_EDGE_ROW_79_Right_98 VGND VDPWR sky130_fd_sc_hd__tapvpwrvgnd_1
XTAP_TAPCELL_ROW_70_311 VGND VDPWR sky130_fd_sc_hd__tapvpwrvgnd_1
XFILLER_70_52 VGND VGND VDPWR VDPWR sky130_fd_sc_hd__decap_3
X_1350_ _1350_/A _1350_/B VGND VGND VDPWR VDPWR _1430_/B sky130_fd_sc_hd__and2_1
X_1281_ _1326_/A _1280_/Y _1204_/B VGND VGND VDPWR VDPWR _1285_/B sky130_fd_sc_hd__a21oi_1
XFILLER_48_162 VGND VGND VDPWR VDPWR sky130_fd_sc_hd__decap_3
XFILLER_48_195 VGND VGND VDPWR VDPWR sky130_fd_sc_hd__decap_3
XFILLER_63_121 VGND VGND VDPWR VDPWR sky130_fd_sc_hd__fill_1
Xclkbuf_leaf_0_clk clkbuf_leaf_7_clk/A VGND VGND VDPWR VDPWR clkbuf_leaf_0_clk/X sky130_fd_sc_hd__clkbuf_2
X_1617_ _1950_/A _1483_/B _1814_/A _1616_/Y _1352_/X VGND VGND VDPWR VDPWR _2046_/A
+ sky130_fd_sc_hd__a41o_1
XFILLER_54_110 VGND VGND VDPWR VDPWR sky130_fd_sc_hd__decap_3
X_1548_ _1553_/A _1548_/B VGND VGND VDPWR VDPWR _1548_/Y sky130_fd_sc_hd__nor2_1
X_1479_ _2151_/Q _2043_/B VGND VGND VDPWR VDPWR _1479_/Y sky130_fd_sc_hd__nor2_1
XFILLER_10_235 VGND VGND VDPWR VDPWR sky130_fd_sc_hd__fill_1
XFILLER_40_66 VGND VGND VDPWR VDPWR sky130_fd_sc_hd__fill_2
XFILLER_6_217 VGND VGND VDPWR VDPWR sky130_fd_sc_hd__decap_3
XPHY_EDGE_ROW_35_2_2_Left_24 VGND VDPWR sky130_fd_sc_hd__tapvpwrvgnd_1
XFILLER_45_121 VGND VGND VDPWR VDPWR sky130_fd_sc_hd__fill_2
XFILLER_65_41 VGND VGND VDPWR VDPWR sky130_fd_sc_hd__decap_3
XPHY_EDGE_ROW_15_2_2_Right_34 VGND VDPWR sky130_fd_sc_hd__tapvpwrvgnd_1
X_1402_ _1403_/A wire73/X VGND VGND VDPWR VDPWR _1463_/A sky130_fd_sc_hd__nor2_1
XFILLER_68_246 VGND VGND VDPWR VDPWR sky130_fd_sc_hd__fill_2
X_1333_ _1339_/A _1334_/B VGND VGND VDPWR VDPWR _1333_/X sky130_fd_sc_hd__or2_1
X_1264_ _1471_/B _1263_/Y _1221_/B VGND VGND VDPWR VDPWR _1264_/Y sky130_fd_sc_hd__a21oi_1
XFILLER_36_132 VGND VGND VDPWR VDPWR sky130_fd_sc_hd__decap_3
X_1195_ _1593_/A _1215_/D VGND VGND VDPWR VDPWR _1757_/C sky130_fd_sc_hd__nand2_1
XFILLER_3_209 VGND VGND VDPWR VDPWR sky130_fd_sc_hd__fill_2
XFILLER_35_33 VGND VGND VDPWR VDPWR sky130_fd_sc_hd__fill_1
XFILLER_42_146 VGND VGND VDPWR VDPWR sky130_fd_sc_hd__fill_2
XFILLER_42_157 VGND VGND VDPWR VDPWR sky130_fd_sc_hd__decap_3
XPHY_EDGE_ROW_36_2_2_Left_25 VGND VDPWR sky130_fd_sc_hd__tapvpwrvgnd_1
Xdelaybuf_5_clk delaybuf_5_clk/A VGND VGND VDPWR VDPWR delaybuf_6_clk/A sky130_fd_sc_hd__clkbuf_2
XTAP_TAPCELL_ROW_43_174 VGND VDPWR sky130_fd_sc_hd__tapvpwrvgnd_1
X_1951_ _2124_/Q _1951_/B _1951_/C VGND VGND VDPWR VDPWR _1951_/Y sky130_fd_sc_hd__nand3_1
X_1882_ _2108_/Q _1881_/X _1729_/A VGND VGND VDPWR VDPWR _1883_/B sky130_fd_sc_hd__o21ai_1
XTAP_TAPCELL_ROW_36_2_2_153 VGND VDPWR sky130_fd_sc_hd__tapvpwrvgnd_1
XFILLER_56_205 VGND VGND VDPWR VDPWR sky130_fd_sc_hd__fill_2
X_1316_ _1841_/S _1316_/B VGND VGND VDPWR VDPWR _1316_/Y sky130_fd_sc_hd__nor2_1
X_1247_ _1134_/A _1169_/A _1185_/Y _1121_/D VGND VGND VDPWR VDPWR _1247_/Y sky130_fd_sc_hd__a22oi_1
X_1178_ _1841_/S _1166_/Y _1242_/B _1235_/B _1177_/Y VGND VGND VDPWR VDPWR _1178_/Y
+ sky130_fd_sc_hd__a311oi_1
XTAP_TAPCELL_ROW_66_288 VGND VDPWR sky130_fd_sc_hd__tapvpwrvgnd_1
XFILLER_47_216 VGND VGND VDPWR VDPWR sky130_fd_sc_hd__fill_1
XFILLER_62_208 VGND VGND VDPWR VDPWR sky130_fd_sc_hd__fill_2
XTAP_TAPCELL_ROW_57_244 VGND VDPWR sky130_fd_sc_hd__tapvpwrvgnd_1
Xmax_cap88 wire89/X VGND VGND VDPWR VDPWR _1221_/B sky130_fd_sc_hd__clkbuf_2
Xmax_cap99 _1174_/B VGND VGND VDPWR VDPWR _1142_/B sky130_fd_sc_hd__buf_2
XPHY_EDGE_ROW_37_2_2_Left_26 VGND VDPWR sky130_fd_sc_hd__tapvpwrvgnd_1
XFILLER_38_227 VGND VGND VDPWR VDPWR sky130_fd_sc_hd__fill_1
XTAP_TAPCELL_ROW_48_200 VGND VDPWR sky130_fd_sc_hd__tapvpwrvgnd_1
X_1032_ _1033_/A _1033_/C VGND VGND VDPWR VDPWR _1134_/C sky130_fd_sc_hd__nor2_1
X_2150_ _2151_/CLK _2150_/D _2044_/A VGND VGND VDPWR VDPWR _2150_/Q sky130_fd_sc_hd__dfrtp_1
X_2081_ clkload9/A _2081_/D VGND VGND VDPWR VDPWR hold47/A sky130_fd_sc_hd__dfxtp_1
X_1101_ _1124_/C _1485_/A _1102_/C VGND VGND VDPWR VDPWR _1498_/A sky130_fd_sc_hd__nor3_1
XFILLER_46_293 VGND VGND VDPWR VDPWR sky130_fd_sc_hd__decap_3
X_1934_ _1934_/A _1934_/B VGND VGND VDPWR VDPWR _1934_/Y sky130_fd_sc_hd__nand2_1
X_1865_ _2050_/Q _1632_/Y _1881_/D _2108_/Q VGND VGND VDPWR VDPWR _1866_/B sky130_fd_sc_hd__a22oi_1
X_1796_ _1795_/A _1795_/B _1616_/A VGND VGND VDPWR VDPWR _1796_/Y sky130_fd_sc_hd__o21ai_1
XFILLER_32_56 VGND VGND VDPWR VDPWR sky130_fd_sc_hd__decap_3
XFILLER_32_78 VGND VGND VDPWR VDPWR sky130_fd_sc_hd__decap_3
XPHY_EDGE_ROW_60_Right_79 VGND VDPWR sky130_fd_sc_hd__tapvpwrvgnd_1
XFILLER_43_230 VGND VGND VDPWR VDPWR sky130_fd_sc_hd__decap_3
XFILLER_43_252 VGND VGND VDPWR VDPWR sky130_fd_sc_hd__fill_1
Xu_sub.u_core.u_regfile.g_nibsel\[1\].g_nib\[3\].u_hi u_sub.u_core.u_regfile.g_word\[1\].g_byte\[2\].u_lat/Q3
+ u_sub.u_core.u_regfile.g_word\[1\].g_byte\[2\].u_lat/Q7 u_sub.u_core.u_regfile.g_word\[1\].g_byte\[3\].u_lat/Q3
+ u_sub.u_core.u_regfile.g_word\[1\].g_byte\[3\].u_lat/Q7 wire83/X _1574_/Y VGND VGND
+ VDPWR VDPWR u_sub.u_core.u_regfile.g_nibsel\[1\].g_nib\[3\].u_hi/X tg_mux4_x1
X_1650_ hold152/X _2164_/Q _1652_/S VGND VGND VDPWR VDPWR _2208_/D sky130_fd_sc_hd__mux2_1
X_1581_ _1581_/A _1581_/B VGND VGND VDPWR VDPWR _1582_/B sky130_fd_sc_hd__xnor2_1
XPHY_EDGE_ROW_17_2_2_Left_6 VGND VDPWR sky130_fd_sc_hd__tapvpwrvgnd_1
XPHY_EDGE_ROW_38_2_2_Left_27 VGND VDPWR sky130_fd_sc_hd__tapvpwrvgnd_1
X_2202_ _2207_/CLK hold27/X VGND VGND VDPWR VDPWR hold28/A sky130_fd_sc_hd__dfxtp_1
XFILLER_34_230 VGND VGND VDPWR VDPWR sky130_fd_sc_hd__fill_1
X_1015_ _1142_/B VGND VGND VDPWR VDPWR _1167_/A sky130_fd_sc_hd__inv_1
X_2133_ _2151_/CLK _2133_/D VGND VGND VDPWR VDPWR _2133_/Q sky130_fd_sc_hd__dfxtp_1
X_2064_ _2151_/CLK _2064_/D VGND VGND VDPWR VDPWR _2064_/Q sky130_fd_sc_hd__dfxtp_1
X_1917_ _2124_/Q _1932_/B VGND VGND VDPWR VDPWR _1939_/B sky130_fd_sc_hd__nor2_1
X_1848_ _2075_/Q wire7/X _1847_/X _1846_/X _1429_/D VGND VGND VDPWR VDPWR _1849_/B
+ sky130_fd_sc_hd__a32oi_1
X_1779_ hold151/X _2215_/D _1779_/S VGND VGND VDPWR VDPWR _2090_/D sky130_fd_sc_hd__mux2_1
XFILLER_40_244 VGND VGND VDPWR VDPWR sky130_fd_sc_hd__decap_3
XFILLER_68_41 VGND VGND VDPWR VDPWR sky130_fd_sc_hd__decap_3
XFILLER_48_344 VGND VGND VDPWR VDPWR sky130_fd_sc_hd__fill_1
XFILLER_31_211 VGND VGND VDPWR VDPWR sky130_fd_sc_hd__fill_1
XFILLER_31_233 VGND VGND VDPWR VDPWR sky130_fd_sc_hd__decap_3
X_1702_ _1729_/A _1714_/B _1702_/C VGND VGND VDPWR VDPWR _2062_/D sky130_fd_sc_hd__and3_1
X_1633_ _1942_/A _1676_/B VGND VGND VDPWR VDPWR _1691_/A sky130_fd_sc_hd__nand2b_1
X_1564_ _1564_/A _1770_/B VGND VGND VDPWR VDPWR _1790_/A sky130_fd_sc_hd__nand2_1
XFILLER_39_344 VGND VGND VDPWR VDPWR sky130_fd_sc_hd__fill_1
XFILLER_66_141 VGND VGND VDPWR VDPWR sky130_fd_sc_hd__decap_3
XFILLER_66_152 VGND VGND VDPWR VDPWR sky130_fd_sc_hd__fill_2
XPHY_EDGE_ROW_39_2_2_Left_28 VGND VDPWR sky130_fd_sc_hd__tapvpwrvgnd_1
X_1495_ _1487_/C _1475_/A _1494_/Y VGND VGND VDPWR VDPWR _2155_/D sky130_fd_sc_hd__o21ai_1
XFILLER_22_200 VGND VGND VDPWR VDPWR sky130_fd_sc_hd__decap_3
XFILLER_66_196 VGND VGND VDPWR VDPWR sky130_fd_sc_hd__decap_3
X_2116_ _2160_/CLK _2116_/D VGND VGND VDPWR VDPWR _2116_/Q sky130_fd_sc_hd__dfxtp_1
X_2047_ _1839_/A _1854_/Y _1857_/Y _1859_/Y VGND VGND VDPWR VDPWR _2100_/D sky130_fd_sc_hd__a31oi_1
XFILLER_38_66 VGND VGND VDPWR VDPWR sky130_fd_sc_hd__fill_2
XFILLER_57_174 VGND VGND VDPWR VDPWR sky130_fd_sc_hd__decap_3
XFILLER_70_31 VGND VGND VDPWR VDPWR sky130_fd_sc_hd__decap_3
XFILLER_9_226 VGND VGND VDPWR VDPWR sky130_fd_sc_hd__decap_3
XFILLER_70_64 VGND VGND VDPWR VDPWR sky130_fd_sc_hd__decap_3
XFILLER_70_75 VGND VGND VDPWR VDPWR sky130_fd_sc_hd__fill_1
X_1280_ _1350_/A _1280_/B VGND VGND VDPWR VDPWR _1280_/Y sky130_fd_sc_hd__nand2_1
X_1616_ _1616_/A _2091_/Q _1814_/A VGND VGND VDPWR VDPWR _1616_/Y sky130_fd_sc_hd__nand3_1
X_1547_ _1552_/A _1548_/B VGND VGND VDPWR VDPWR _1547_/Y sky130_fd_sc_hd__nor2_1
XFILLER_39_141 VGND VGND VDPWR VDPWR sky130_fd_sc_hd__fill_2
XFILLER_54_144 VGND VGND VDPWR VDPWR sky130_fd_sc_hd__fill_2
X_1478_ _2150_/Q _1478_/B VGND VGND VDPWR VDPWR _1482_/B sky130_fd_sc_hd__nand2_1
XFILLER_42_339 VGND VGND VDPWR VDPWR sky130_fd_sc_hd__fill_1
XFILLER_54_166 VGND VGND VDPWR VDPWR sky130_fd_sc_hd__decap_3
XFILLER_33_339 VGND VGND VDPWR VDPWR sky130_fd_sc_hd__fill_1
XFILLER_45_133 VGND VGND VDPWR VDPWR sky130_fd_sc_hd__decap_3
XFILLER_65_64 VGND VGND VDPWR VDPWR sky130_fd_sc_hd__decap_3
XFILLER_60_147 VGND VGND VDPWR VDPWR sky130_fd_sc_hd__fill_1
XFILLER_60_169 VGND VGND VDPWR VDPWR sky130_fd_sc_hd__fill_1
Xu_sub.u_core.u_regfile.g_word\[1\].g_byte\[3\].u_lat max_cap121/X max_cap119/X wire116/A
+ max_cap115/X wire112/A max_cap111/X max_cap109/X _2100_/Q u_sub.u_core.u_regfile.g_word\[1\].g_byte\[3\].u_lat/GATE
+ VGND VDPWR u_sub.u_core.u_regfile.g_word\[1\].g_byte\[3\].u_lat/Q0 u_sub.u_core.u_regfile.g_word\[1\].g_byte\[3\].u_lat/Q1
+ u_sub.u_core.u_regfile.g_word\[1\].g_byte\[3\].u_lat/Q2 u_sub.u_core.u_regfile.g_word\[1\].g_byte\[3\].u_lat/Q3
+ u_sub.u_core.u_regfile.g_word\[1\].g_byte\[3\].u_lat/Q4 u_sub.u_core.u_regfile.g_word\[1\].g_byte\[3\].u_lat/Q5
+ u_sub.u_core.u_regfile.g_word\[1\].g_byte\[3\].u_lat/Q6 u_sub.u_core.u_regfile.g_word\[1\].g_byte\[3\].u_lat/Q7
+ dlxtp8_x1
XFILLER_68_203 VGND VGND VDPWR VDPWR sky130_fd_sc_hd__fill_1
X_1401_ _1549_/A wire73/X VGND VGND VDPWR VDPWR _1401_/Y sky130_fd_sc_hd__nand2_1
X_1332_ _1339_/A _1334_/B VGND VGND VDPWR VDPWR _1332_/X sky130_fd_sc_hd__and2_1
X_1263_ _1263_/A _1263_/B VGND VGND VDPWR VDPWR _1263_/Y sky130_fd_sc_hd__nor2_1
X_1194_ _1199_/A _1199_/B VGND VGND VDPWR VDPWR _1212_/B sky130_fd_sc_hd__or2_1
XFILLER_59_236 VGND VGND VDPWR VDPWR sky130_fd_sc_hd__fill_2
XFILLER_27_188 VGND VGND VDPWR VDPWR sky130_fd_sc_hd__decap_3
XFILLER_65_217 VGND VGND VDPWR VDPWR sky130_fd_sc_hd__fill_1
XPHY_EDGE_ROW_69_Left_128 VGND VDPWR sky130_fd_sc_hd__tapvpwrvgnd_1
XTAP_TAPCELL_ROW_43_175 VGND VDPWR sky130_fd_sc_hd__tapvpwrvgnd_1
X_1950_ _1950_/A hold45/A VGND VGND VDPWR VDPWR _1951_/C sky130_fd_sc_hd__nand2_1
XPHY_EDGE_ROW_78_Left_137 VGND VDPWR sky130_fd_sc_hd__tapvpwrvgnd_1
X_1881_ _2102_/Q _1881_/B _1881_/C _1881_/D VGND VGND VDPWR VDPWR _1881_/X sky130_fd_sc_hd__and4b_1
XFILLER_37_1 VGND VGND VDPWR VDPWR sky130_fd_sc_hd__decap_3
X_1315_ _1006_/Y _1647_/B _1757_/A _1313_/Y _1314_/Y VGND VGND VDPWR VDPWR _1339_/A
+ sky130_fd_sc_hd__o221ai_1
XTAP_TAPCELL_ROW_66_289 VGND VDPWR sky130_fd_sc_hd__tapvpwrvgnd_1
X_1246_ _1326_/A _1245_/Y _1746_/A VGND VGND VDPWR VDPWR _1250_/B sky130_fd_sc_hd__a21oi_1
X_1177_ _1174_/B _1170_/Y _1176_/Y _1167_/Y _1841_/S VGND VGND VDPWR VDPWR _1177_/Y
+ sky130_fd_sc_hd__a2111oi_1
XANTENNA_10 uio_in[7] VGND VGND VDPWR VDPWR sky130_fd_sc_hd__diode_2
XFILLER_47_228 VGND VGND VDPWR VDPWR sky130_fd_sc_hd__decap_3
XFILLER_46_66 VGND VGND VDPWR VDPWR sky130_fd_sc_hd__fill_2
XTAP_TAPCELL_ROW_57_245 VGND VDPWR sky130_fd_sc_hd__tapvpwrvgnd_1
Xmax_cap78 _1869_/A VGND VGND VDPWR VDPWR _1875_/A sky130_fd_sc_hd__clkbuf_2
Xu_sub.u_core.u_regfile.g_nibsel\[4\].g_nib\[2\].u_lo u_sub.u_core.u_regfile.g_word\[4\].g_byte\[0\].u_lat/Q2
+ u_sub.u_core.u_regfile.g_word\[4\].g_byte\[0\].u_lat/Q6 u_sub.u_core.u_regfile.g_word\[4\].g_byte\[1\].u_lat/Q2
+ u_sub.u_core.u_regfile.g_word\[4\].g_byte\[1\].u_lat/Q6 max_cap5/X max_cap3/X VGND
+ VGND VDPWR VDPWR u_sub.u_core.u_regfile.g_nibsel\[4\].g_nib\[2\].u_lo/X tg_mux4_x1
XFILLER_23_191 VGND VGND VDPWR VDPWR sky130_fd_sc_hd__decap_3
Xu_sub.u_core.u_regfile.g_port\[3\].u_za u_sub.u_core.u_regfile.g_port\[3\].u_a/X
+ _1154_/Y VGND VGND VDPWR VDPWR _1006_/A sky130_fd_sc_hd__and2_1
XFILLER_46_283 VGND VGND VDPWR VDPWR sky130_fd_sc_hd__fill_2
XTAP_TAPCELL_ROW_48_201 VGND VDPWR sky130_fd_sc_hd__tapvpwrvgnd_1
X_1031_ _1057_/B _1376_/B _1188_/A VGND VGND VDPWR VDPWR _1046_/C sky130_fd_sc_hd__nor3_1
X_2080_ clkload8/A _2080_/D _2044_/A VGND VGND VDPWR VDPWR _2080_/Q sky130_fd_sc_hd__dfrtp_1
X_1100_ _1757_/A _1096_/Y _1099_/Y VGND VGND VDPWR VDPWR _1212_/A sky130_fd_sc_hd__o21ai_1
XFILLER_14_191 VGND VGND VDPWR VDPWR sky130_fd_sc_hd__decap_3
X_1933_ _2128_/Q _1932_/B _1914_/B _1932_/Y VGND VGND VDPWR VDPWR _1934_/B sky130_fd_sc_hd__o211ai_1
Xu_sub.u_core.u_regfile.g_nibsel\[2\].g_nib\[1\].u_hi u_sub.u_core.u_regfile.g_word\[2\].g_byte\[2\].u_lat/Q1
+ u_sub.u_core.u_regfile.g_word\[2\].g_byte\[2\].u_lat/Q5 u_sub.u_core.u_regfile.g_word\[2\].g_byte\[3\].u_lat/Q1
+ u_sub.u_core.u_regfile.g_word\[2\].g_byte\[3\].u_lat/Q5 max_cap4/X max_cap2/X VGND
+ VGND VDPWR VDPWR u_sub.u_core.u_regfile.g_nibsel\[2\].g_nib\[1\].u_hi/X tg_mux4_x1
X_1864_ _1864_/A _1729_/A VGND VGND VDPWR VDPWR _2102_/D sky130_fd_sc_hd__nor2b_1
X_1795_ _1795_/A _1795_/B VGND VGND VDPWR VDPWR _1795_/X sky130_fd_sc_hd__or2_1
XFILLER_52_253 VGND VGND VDPWR VDPWR sky130_fd_sc_hd__decap_3
X_1229_ hold54/A _1024_/B _1204_/B _2164_/Q VGND VGND VDPWR VDPWR _1230_/C sky130_fd_sc_hd__o22ai_1
XFILLER_32_13 VGND VGND VDPWR VDPWR sky130_fd_sc_hd__decap_3
XFILLER_32_35 VGND VGND VDPWR VDPWR sky130_fd_sc_hd__fill_2
XTAP_TAPCELL_ROW_62_270 VGND VDPWR sky130_fd_sc_hd__tapvpwrvgnd_1
XPHY_EDGE_ROW_41_1_1_Left_100 VGND VDPWR sky130_fd_sc_hd__tapvpwrvgnd_1
XFILLER_57_54 VGND VGND VDPWR VDPWR sky130_fd_sc_hd__fill_1
X_1580_ _2077_/Q _1580_/B VGND VGND VDPWR VDPWR _1581_/B sky130_fd_sc_hd__xnor2_1
X_2201_ _2210_/CLK hold32/X VGND VGND VDPWR VDPWR hold36/A sky130_fd_sc_hd__dfxtp_1
X_2132_ _2151_/CLK _2132_/D VGND VGND VDPWR VDPWR _2132_/Q sky130_fd_sc_hd__dfxtp_1
XTAP_TAPCELL_ROW_76_340 VGND VDPWR sky130_fd_sc_hd__tapvpwrvgnd_1
X_1014_ _1118_/A VGND VGND VDPWR VDPWR _1141_/B sky130_fd_sc_hd__inv_1
X_2063_ clkload7/A _2063_/D VGND VGND VDPWR VDPWR _2063_/Q sky130_fd_sc_hd__dfxtp_1
X_1916_ _2125_/Q _1930_/A VGND VGND VDPWR VDPWR _1941_/A sky130_fd_sc_hd__nand2b_1
X_1847_ _2105_/Q _1881_/B _1787_/C _1665_/D VGND VGND VDPWR VDPWR _1847_/X sky130_fd_sc_hd__a22o_1
X_1778_ hold146/X _2214_/D _1779_/S VGND VGND VDPWR VDPWR _2089_/D sky130_fd_sc_hd__mux2_1
XFILLER_25_220 VGND VGND VDPWR VDPWR sky130_fd_sc_hd__fill_1
XFILLER_43_67 VGND VGND VDPWR VDPWR sky130_fd_sc_hd__fill_2
XFILLER_43_89 VGND VGND VDPWR VDPWR sky130_fd_sc_hd__decap_3
XFILLER_68_53 VGND VGND VDPWR VDPWR sky130_fd_sc_hd__decap_3
Xu_sub.u_core.u_regfile.g_word\[3\].g_byte\[2\].u_cg.u_icg clkload1/A _1542_/Y VGND
+ VGND VDPWR VDPWR u_sub.u_core.u_regfile.g_word\[3\].g_byte\[2\].u_lat/GATE sky130_fd_sc_hd__dlclkp_1
X_1701_ _1701_/A _1704_/B VGND VGND VDPWR VDPWR _1702_/C sky130_fd_sc_hd__nor2_1
XFILLER_69_4 VGND VGND VDPWR VDPWR sky130_fd_sc_hd__decap_3
X_1632_ _1942_/A _1676_/B VGND VGND VDPWR VDPWR _1632_/Y sky130_fd_sc_hd__nor2b_1
X_1563_ _1753_/A _1586_/A VGND VGND VDPWR VDPWR _1771_/A sky130_fd_sc_hd__nand2_1
X_1494_ _2043_/B _1477_/B _2155_/Q VGND VGND VDPWR VDPWR _1494_/Y sky130_fd_sc_hd__o21ai_1
X_2115_ _2151_/CLK _2115_/D VGND VGND VDPWR VDPWR _2115_/Q sky130_fd_sc_hd__dfxtp_1
XFILLER_22_212 VGND VGND VDPWR VDPWR sky130_fd_sc_hd__fill_1
X_2046_ _2046_/A _2046_/B _2046_/C VGND VGND VDPWR VDPWR _2099_/D sky130_fd_sc_hd__nor3_1
XFILLER_54_66 VGND VGND VDPWR VDPWR sky130_fd_sc_hd__fill_2
XFILLER_57_164 VGND VGND VDPWR VDPWR sky130_fd_sc_hd__decap_3
XFILLER_57_186 VGND VGND VDPWR VDPWR sky130_fd_sc_hd__decap_3
XFILLER_70_10 VGND VGND VDPWR VDPWR sky130_fd_sc_hd__decap_3
XFILLER_70_43 VGND VGND VDPWR VDPWR sky130_fd_sc_hd__decap_3
XFILLER_9_216 VGND VGND VDPWR VDPWR sky130_fd_sc_hd__fill_1
XFILLER_48_153 VGND VGND VDPWR VDPWR sky130_fd_sc_hd__decap_3
XFILLER_63_112 VGND VGND VDPWR VDPWR sky130_fd_sc_hd__decap_3
XPHY_EDGE_ROW_50_Left_109 VGND VDPWR sky130_fd_sc_hd__tapvpwrvgnd_1
XFILLER_51_307 VGND VGND VDPWR VDPWR sky130_fd_sc_hd__fill_1
XFILLER_67_1 VGND VGND VDPWR VDPWR sky130_fd_sc_hd__decap_3
X_1615_ _1615_/A _1615_/B VGND VGND VDPWR VDPWR _1641_/A sky130_fd_sc_hd__nor2_1
X_1546_ _1551_/A _1548_/B VGND VGND VDPWR VDPWR _1546_/Y sky130_fd_sc_hd__nor2_1
X_1477_ _1477_/A _1477_/B VGND VGND VDPWR VDPWR _2150_/D sky130_fd_sc_hd__nand2_1
XFILLER_54_123 VGND VGND VDPWR VDPWR sky130_fd_sc_hd__fill_2
X_2029_ _2141_/Q _2027_/A _2028_/Y VGND VGND VDPWR VDPWR _2141_/D sky130_fd_sc_hd__a21oi_1
Xdelaybuf_15_clk clkload1/A VGND VGND VDPWR VDPWR delaybuf_15_clk/X sky130_fd_sc_hd__clkbuf_2
XFILLER_45_145 VGND VGND VDPWR VDPWR sky130_fd_sc_hd__decap_3
XFILLER_5_230 VGND VGND VDPWR VDPWR sky130_fd_sc_hd__decap_3
X_1400_ hold23/A _1381_/Y _1382_/Y wire79/X VGND VGND VDPWR VDPWR wire73/A sky130_fd_sc_hd__o31ai_1
X_1331_ _1331_/A _1339_/B VGND VGND VDPWR VDPWR _1334_/B sky130_fd_sc_hd__xor2_1
XFILLER_36_145 VGND VGND VDPWR VDPWR sky130_fd_sc_hd__decap_3
X_1262_ _1211_/A _1257_/X _1260_/B _1337_/B VGND VGND VDPWR VDPWR _1263_/B sky130_fd_sc_hd__o22ai_1
X_1193_ _1314_/B _1164_/Y _1184_/Y _1192_/Y _1110_/C VGND VGND VDPWR VDPWR _1199_/B
+ sky130_fd_sc_hd__a221oi_1
XFILLER_59_215 VGND VGND VDPWR VDPWR sky130_fd_sc_hd__decap_3
X_1529_ _1529_/A _1531_/B VGND VGND VDPWR VDPWR _1552_/A sky130_fd_sc_hd__nand2_1
XFILLER_35_35 VGND VGND VDPWR VDPWR sky130_fd_sc_hd__decap_3
XFILLER_2_200 VGND VGND VDPWR VDPWR sky130_fd_sc_hd__decap_3
XFILLER_2_222 VGND VGND VDPWR VDPWR sky130_fd_sc_hd__decap_3
XFILLER_33_137 VGND VGND VDPWR VDPWR sky130_fd_sc_hd__fill_1
XTAP_TAPCELL_ROW_43_176 VGND VDPWR sky130_fd_sc_hd__tapvpwrvgnd_1
X_1880_ wire70/X _1890_/B VGND VGND VDPWR VDPWR _1883_/A sky130_fd_sc_hd__nor2_1
X_1314_ _2166_/Q _1314_/B VGND VGND VDPWR VDPWR _1314_/Y sky130_fd_sc_hd__nand2_1
XFILLER_49_270 VGND VGND VDPWR VDPWR sky130_fd_sc_hd__decap_3
X_1245_ _1458_/B _1280_/B VGND VGND VDPWR VDPWR _1245_/Y sky130_fd_sc_hd__nand2_1
X_1176_ _1242_/A _1174_/C _1153_/C VGND VGND VDPWR VDPWR _1176_/Y sky130_fd_sc_hd__a21boi_1
XANTENNA_11 wire10/A VGND VGND VDPWR VDPWR sky130_fd_sc_hd__diode_2
XTAP_TAPCELL_ROW_57_246 VGND VDPWR sky130_fd_sc_hd__tapvpwrvgnd_1
Xmax_cap13 _2044_/A VGND VGND VDPWR VDPWR _1729_/A sky130_fd_sc_hd__buf_12
XFILLER_46_78 VGND VGND VDPWR VDPWR sky130_fd_sc_hd__decap_3
Xmax_cap68 _1956_/A1 VGND VGND VDPWR VDPWR _2214_/D sky130_fd_sc_hd__buf_6
Xu_sub.u_core.u_regfile.g_port\[3\].u_zb u_sub.u_core.u_regfile.g_port\[3\].u_b/X
+ _1146_/X VGND VGND VDPWR VDPWR _2215_/D sky130_fd_sc_hd__and2_1
XPHY_EDGE_ROW_27_2_2_Right_46 VGND VDPWR sky130_fd_sc_hd__tapvpwrvgnd_1
X_1030_ _1458_/B _1188_/A VGND VGND VDPWR VDPWR _1030_/Y sky130_fd_sc_hd__nor2_1
X_1932_ _2038_/A _1932_/B VGND VGND VDPWR VDPWR _1932_/Y sky130_fd_sc_hd__nand2_1
X_1863_ _2102_/Q _1721_/B _1879_/A VGND VGND VDPWR VDPWR _1864_/A sky130_fd_sc_hd__a21oi_1
X_1794_ _2101_/Q _1753_/B _1211_/B _1257_/X _1299_/Y VGND VGND VDPWR VDPWR _1795_/B
+ sky130_fd_sc_hd__o2111ai_1
X_1228_ hold59/A _1746_/A VGND VGND VDPWR VDPWR _1230_/B sky130_fd_sc_hd__nor2_1
XTAP_TAPCELL_ROW_54_227 VGND VDPWR sky130_fd_sc_hd__tapvpwrvgnd_1
XTAP_TAPCELL_ROW_62_271 VGND VDPWR sky130_fd_sc_hd__tapvpwrvgnd_1
X_1159_ _1140_/Y _1143_/X _1154_/Y _1155_/Y VGND VGND VDPWR VDPWR _1160_/D sky130_fd_sc_hd__o22ai_1
XFILLER_32_25 VGND VGND VDPWR VDPWR sky130_fd_sc_hd__decap_3
XFILLER_32_47 VGND VGND VDPWR VDPWR sky130_fd_sc_hd__decap_3
XFILLER_32_69 VGND VGND VDPWR VDPWR sky130_fd_sc_hd__decap_3
XFILLER_43_243 VGND VGND VDPWR VDPWR sky130_fd_sc_hd__decap_3
Xu_sub.u_core.u_regfile.g_nibsel\[1\].g_nib\[3\].u_lo u_sub.u_core.u_regfile.g_word\[1\].g_byte\[0\].u_lat/Q3
+ u_sub.u_core.u_regfile.g_word\[1\].g_byte\[0\].u_lat/Q7 u_sub.u_core.u_regfile.g_word\[1\].g_byte\[1\].u_lat/Q3
+ u_sub.u_core.u_regfile.g_word\[1\].g_byte\[1\].u_lat/Q7 wire83/X _1574_/Y VGND VGND
+ VDPWR VDPWR u_sub.u_core.u_regfile.g_nibsel\[1\].g_nib\[3\].u_lo/X tg_mux4_x1
XTAP_TAPCELL_ROW_76_341 VGND VDPWR sky130_fd_sc_hd__tapvpwrvgnd_1
X_2200_ _2210_/CLK hold33/X VGND VGND VDPWR VDPWR hold29/A sky130_fd_sc_hd__dfxtp_1
X_2131_ _2151_/CLK _2131_/D VGND VGND VDPWR VDPWR _2131_/Q sky130_fd_sc_hd__dfxtp_1
X_2062_ clkload7/A _2062_/D VGND VGND VDPWR VDPWR _2062_/Q sky130_fd_sc_hd__dfxtp_1
X_1013_ _1798_/A VGND VGND VDPWR VDPWR _1360_/B sky130_fd_sc_hd__inv_1
X_1915_ _2125_/Q _2124_/Q VGND VGND VDPWR VDPWR _1915_/Y sky130_fd_sc_hd__nand2_1
X_1846_ _1846_/A0 _1846_/A1 _2075_/Q VGND VGND VDPWR VDPWR _1846_/X sky130_fd_sc_hd__mux2_1
X_1777_ hold147/X _1777_/A1 _1779_/S VGND VGND VDPWR VDPWR _2088_/D sky130_fd_sc_hd__mux2_1
XFILLER_40_279 VGND VGND VDPWR VDPWR sky130_fd_sc_hd__decap_3
XFILLER_43_35 VGND VGND VDPWR VDPWR sky130_fd_sc_hd__decap_3
XFILLER_68_10 VGND VGND VDPWR VDPWR sky130_fd_sc_hd__decap_3
XFILLER_63_305 VGND VGND VDPWR VDPWR sky130_fd_sc_hd__fill_1
XTAP_TAPCELL_ROW_73_322 VGND VDPWR sky130_fd_sc_hd__tapvpwrvgnd_1
XPHY_EDGE_ROW_11_2_2_Right_30 VGND VDPWR sky130_fd_sc_hd__tapvpwrvgnd_1
X_1700_ _2071_/Q _2070_/Q _2061_/Q _2062_/Q VGND VGND VDPWR VDPWR _1704_/B sky130_fd_sc_hd__and4_1
X_1631_ hold67/A _2164_/Q _1959_/A VGND VGND VDPWR VDPWR _1942_/A sky130_fd_sc_hd__mux2_1
Xclkbuf_leaf_3_clk clkbuf_leaf_7_clk/A VGND VGND VDPWR VDPWR clkbuf_leaf_3_clk/X sky130_fd_sc_hd__clkbuf_2
X_1562_ _1756_/B _1562_/B VGND VGND VDPWR VDPWR _1770_/B sky130_fd_sc_hd__nor2_1
X_1493_ _1590_/B _1562_/B _1487_/Y _1492_/Y VGND VGND VDPWR VDPWR _2156_/D sky130_fd_sc_hd__o31ai_1
X_2114_ _2151_/CLK _2114_/D VGND VGND VDPWR VDPWR _2114_/Q sky130_fd_sc_hd__dfxtp_1
X_2045_ _1813_/X _1831_/Y _1352_/X VGND VGND VDPWR VDPWR _2098_/D sky130_fd_sc_hd__a21oi_1
XFILLER_22_235 VGND VGND VDPWR VDPWR sky130_fd_sc_hd__fill_1
X_1829_ _2073_/Q _1588_/B _1753_/C _1483_/B VGND VGND VDPWR VDPWR _1829_/Y sky130_fd_sc_hd__a31oi_1
Xu_sub.u_core.u_regfile.g_word\[4\].g_byte\[1\].u_lat max_cap120/X max_cap118/X wire116/A
+ max_cap114/X wire112/A max_cap111/X max_cap108/X max_cap107/X u_sub.u_core.u_regfile.g_word\[4\].g_byte\[1\].u_lat/GATE
+ VGND VDPWR u_sub.u_core.u_regfile.g_word\[4\].g_byte\[1\].u_lat/Q0 u_sub.u_core.u_regfile.g_word\[4\].g_byte\[1\].u_lat/Q1
+ u_sub.u_core.u_regfile.g_word\[4\].g_byte\[1\].u_lat/Q2 u_sub.u_core.u_regfile.g_word\[4\].g_byte\[1\].u_lat/Q3
+ u_sub.u_core.u_regfile.g_word\[4\].g_byte\[1\].u_lat/Q4 u_sub.u_core.u_regfile.g_word\[4\].g_byte\[1\].u_lat/Q5
+ u_sub.u_core.u_regfile.g_word\[4\].g_byte\[1\].u_lat/Q6 u_sub.u_core.u_regfile.g_word\[4\].g_byte\[1\].u_lat/Q7
+ dlxtp8_x1
XFILLER_45_305 VGND VGND VDPWR VDPWR sky130_fd_sc_hd__fill_1
XFILLER_54_89 VGND VGND VDPWR VDPWR sky130_fd_sc_hd__decap_3
XPHY_EDGE_ROW_16_2_2_Left_5 VGND VDPWR sky130_fd_sc_hd__tapvpwrvgnd_1
XFILLER_13_235 VGND VGND VDPWR VDPWR sky130_fd_sc_hd__fill_1
XFILLER_70_22 VGND VGND VDPWR VDPWR sky130_fd_sc_hd__decap_3
XFILLER_70_55 VGND VGND VDPWR VDPWR sky130_fd_sc_hd__decap_3
XPHY_EDGE_ROW_48_Right_67 VGND VDPWR sky130_fd_sc_hd__tapvpwrvgnd_1
XPHY_EDGE_ROW_57_Right_76 VGND VDPWR sky130_fd_sc_hd__tapvpwrvgnd_1
XFILLER_36_338 VGND VGND VDPWR VDPWR sky130_fd_sc_hd__fill_2
XFILLER_48_165 VGND VGND VDPWR VDPWR sky130_fd_sc_hd__decap_3
XFILLER_48_187 VGND VGND VDPWR VDPWR sky130_fd_sc_hd__fill_2
XFILLER_48_198 VGND VGND VDPWR VDPWR sky130_fd_sc_hd__decap_3
XFILLER_63_157 VGND VGND VDPWR VDPWR sky130_fd_sc_hd__fill_1
XPHY_EDGE_ROW_66_Right_85 VGND VDPWR sky130_fd_sc_hd__tapvpwrvgnd_1
XPHY_EDGE_ROW_75_Right_94 VGND VDPWR sky130_fd_sc_hd__tapvpwrvgnd_1
X_1614_ _1595_/Y _1607_/Y _1611_/Y _1612_/Y _1562_/B VGND VGND VDPWR VDPWR _1615_/B
+ sky130_fd_sc_hd__a221oi_1
X_1545_ _1550_/A _1548_/B VGND VGND VDPWR VDPWR _1545_/Y sky130_fd_sc_hd__nor2_1
X_1476_ _2151_/Q _1476_/B VGND VGND VDPWR VDPWR _1477_/B sky130_fd_sc_hd__nand2_1
XFILLER_39_154 VGND VGND VDPWR VDPWR sky130_fd_sc_hd__fill_1
XFILLER_54_113 VGND VGND VDPWR VDPWR sky130_fd_sc_hd__decap_3
XFILLER_54_157 VGND VGND VDPWR VDPWR sky130_fd_sc_hd__fill_2
X_2028_ _2141_/Q _2027_/A _2039_/B VGND VGND VDPWR VDPWR _2028_/Y sky130_fd_sc_hd__o21ai_1
XFILLER_40_69 VGND VGND VDPWR VDPWR sky130_fd_sc_hd__fill_1
XFILLER_65_99 VGND VGND VDPWR VDPWR sky130_fd_sc_hd__decap_3
Xdelaybuf_8_clk delaybuf_8_clk/A VGND VGND VDPWR VDPWR delaybuf_9_clk/A sky130_fd_sc_hd__clkbuf_2
X_1330_ _2215_/D _1109_/Y _1165_/Y _1329_/Y VGND VGND VDPWR VDPWR _1339_/B sky130_fd_sc_hd__a22oi_1
X_1261_ _1302_/A _1260_/Y _1259_/Y VGND VGND VDPWR VDPWR _1263_/A sky130_fd_sc_hd__a21oi_1
XFILLER_36_124 VGND VGND VDPWR VDPWR sky130_fd_sc_hd__fill_1
XFILLER_36_135 VGND VGND VDPWR VDPWR sky130_fd_sc_hd__fill_1
X_1192_ _1442_/A _1186_/X _1187_/X _1189_/Y _1191_/Y VGND VGND VDPWR VDPWR _1192_/Y
+ sky130_fd_sc_hd__a32oi_1
XFILLER_59_249 VGND VGND VDPWR VDPWR sky130_fd_sc_hd__fill_2
X_1528_ _1532_/A _1551_/A VGND VGND VDPWR VDPWR _1528_/Y sky130_fd_sc_hd__nor2_1
X_1459_ _2076_/Q _1458_/Y _1030_/Y VGND VGND VDPWR VDPWR _1461_/B sky130_fd_sc_hd__a21oi_1
XFILLER_51_35 VGND VGND VDPWR VDPWR sky130_fd_sc_hd__decap_3
XFILLER_51_68 VGND VGND VDPWR VDPWR sky130_fd_sc_hd__fill_2
XFILLER_58_271 VGND VGND VDPWR VDPWR sky130_fd_sc_hd__fill_1
XFILLER_65_208 VGND VGND VDPWR VDPWR sky130_fd_sc_hd__fill_2
XFILLER_41_160 VGND VGND VDPWR VDPWR sky130_fd_sc_hd__fill_1
XFILLER_41_171 VGND VGND VDPWR VDPWR sky130_fd_sc_hd__fill_2
X_1313_ _1006_/A _1086_/X _1087_/Y _1312_/Y VGND VGND VDPWR VDPWR _1313_/Y sky130_fd_sc_hd__a22oi_1
X_1244_ _1240_/Y _1243_/Y _2077_/Q VGND VGND VDPWR VDPWR _1244_/Y sky130_fd_sc_hd__o21ai_1
X_1175_ _1169_/A _1169_/Y _1142_/B VGND VGND VDPWR VDPWR _1326_/A sky130_fd_sc_hd__o21ai_1
XANTENNA_12 wire75/X VGND VGND VDPWR VDPWR sky130_fd_sc_hd__diode_2
XFILLER_32_171 VGND VGND VDPWR VDPWR sky130_fd_sc_hd__fill_2
XFILLER_32_193 VGND VGND VDPWR VDPWR sky130_fd_sc_hd__fill_2
Xmax_cap14 _2039_/B VGND VGND VDPWR VDPWR _2044_/A sky130_fd_sc_hd__buf_12
Xmax_cap69 _1777_/A1 VGND VGND VDPWR VDPWR _2213_/D sky130_fd_sc_hd__clkbuf_8
XFILLER_38_219 VGND VGND VDPWR VDPWR sky130_fd_sc_hd__decap_3
XFILLER_46_296 VGND VGND VDPWR VDPWR sky130_fd_sc_hd__fill_1
XFILLER_61_200 VGND VGND VDPWR VDPWR sky130_fd_sc_hd__decap_3
X_1931_ hold24/A _1931_/B VGND VGND VDPWR VDPWR _1934_/A sky130_fd_sc_hd__nand2_1
X_1862_ _1861_/B _1795_/X _1861_/Y VGND VGND VDPWR VDPWR _2101_/D sky130_fd_sc_hd__o21ai_1
X_1793_ _1006_/Y _1792_/B _1792_/C _1789_/Y _1792_/Y VGND VGND VDPWR VDPWR _2091_/D
+ sky130_fd_sc_hd__a221oi_1
XFILLER_69_344 VGND VGND VDPWR VDPWR sky130_fd_sc_hd__fill_1
Xu_sub.u_core.u_regfile.g_nibsel\[2\].g_nib\[1\].u_lo u_sub.u_core.u_regfile.g_word\[2\].g_byte\[0\].u_lat/Q1
+ u_sub.u_core.u_regfile.g_word\[2\].g_byte\[0\].u_lat/Q5 u_sub.u_core.u_regfile.g_word\[2\].g_byte\[1\].u_lat/Q1
+ u_sub.u_core.u_regfile.g_word\[2\].g_byte\[1\].u_lat/Q5 max_cap4/X max_cap2/X VGND
+ VGND VDPWR VDPWR u_sub.u_core.u_regfile.g_nibsel\[2\].g_nib\[1\].u_lo/X tg_mux4_x1
XFILLER_52_200 VGND VGND VDPWR VDPWR sky130_fd_sc_hd__decap_3
X_1227_ hold61/A _1570_/A _1841_/S VGND VGND VDPWR VDPWR _1230_/A sky130_fd_sc_hd__nor3_1
X_1158_ _1404_/A _1135_/Y _1147_/Y _1157_/Y VGND VGND VDPWR VDPWR _1160_/C sky130_fd_sc_hd__o211ai_1
XFILLER_52_211 VGND VGND VDPWR VDPWR sky130_fd_sc_hd__fill_2
XTAP_TAPCELL_ROW_54_228 VGND VDPWR sky130_fd_sc_hd__tapvpwrvgnd_1
X_1089_ _1566_/A _1841_/S VGND VGND VDPWR VDPWR _1241_/A sky130_fd_sc_hd__nor2_1
XFILLER_20_196 VGND VGND VDPWR VDPWR sky130_fd_sc_hd__fill_1
XFILLER_32_59 VGND VGND VDPWR VDPWR sky130_fd_sc_hd__decap_3
XFILLER_43_233 VGND VGND VDPWR VDPWR sky130_fd_sc_hd__decap_3
Xclkbuf_0_u_sub.u_timer.g_cmp\[0\].g clkbuf_0_u_sub.u_timer.g_cmp\[0\].g/A VGND VGND
+ VDPWR VDPWR clkbuf_0_u_sub.u_timer.g_cmp\[0\].g/X sky130_fd_sc_hd__clkbuf_2
X_1012_ _1057_/B VGND VGND VDPWR VDPWR _1616_/A sky130_fd_sc_hd__inv_1
X_2130_ _2151_/CLK _2130_/D VGND VGND VDPWR VDPWR _2130_/Q sky130_fd_sc_hd__dfxtp_1
X_2061_ clkload7/A _2061_/D VGND VGND VDPWR VDPWR _2061_/Q sky130_fd_sc_hd__dfxtp_1
X_1914_ uio_out[0] _1914_/B VGND VGND VDPWR VDPWR _1914_/Y sky130_fd_sc_hd__nor2_1
X_1845_ _1894_/D _1843_/Y _1844_/Y _1842_/Y VGND VGND VDPWR VDPWR _1845_/Y sky130_fd_sc_hd__o211ai_1
X_1776_ _2087_/Q wire70/X _1779_/S VGND VGND VDPWR VDPWR _2087_/D sky130_fd_sc_hd__mux2_1
XFILLER_69_152 VGND VGND VDPWR VDPWR sky130_fd_sc_hd__decap_3
XFILLER_25_222 VGND VGND VDPWR VDPWR sky130_fd_sc_hd__fill_1
XFILLER_40_247 VGND VGND VDPWR VDPWR sky130_fd_sc_hd__fill_1
XFILLER_68_22 VGND VGND VDPWR VDPWR sky130_fd_sc_hd__decap_3
XFILLER_68_44 VGND VGND VDPWR VDPWR sky130_fd_sc_hd__decap_3
XFILLER_48_325 VGND VGND VDPWR VDPWR sky130_fd_sc_hd__fill_2
XTAP_TAPCELL_ROW_73_323 VGND VDPWR sky130_fd_sc_hd__tapvpwrvgnd_1
X_1630_ _1630_/A0 _1630_/A1 _2075_/Q VGND VGND VDPWR VDPWR _1630_/X sky130_fd_sc_hd__mux2_1
XFILLER_3_192 VGND VGND VDPWR VDPWR sky130_fd_sc_hd__decap_3
X_1561_ _1791_/A _2038_/A VGND VGND VDPWR VDPWR _1561_/Y sky130_fd_sc_hd__xnor2_1
X_1492_ _2156_/Q _1506_/B VGND VGND VDPWR VDPWR _1492_/Y sky130_fd_sc_hd__nand2_1
XFILLER_66_144 VGND VGND VDPWR VDPWR sky130_fd_sc_hd__fill_1
XFILLER_66_188 VGND VGND VDPWR VDPWR sky130_fd_sc_hd__decap_3
XFILLER_66_199 VGND VGND VDPWR VDPWR sky130_fd_sc_hd__decap_3
X_2113_ _2151_/CLK _2113_/D VGND VGND VDPWR VDPWR _2113_/Q sky130_fd_sc_hd__dfxtp_1
X_2044_ _2044_/A _2044_/B _2044_/C VGND VGND VDPWR VDPWR _2148_/D sky130_fd_sc_hd__nand3_1
XFILLER_22_203 VGND VGND VDPWR VDPWR sky130_fd_sc_hd__decap_3
X_1828_ _1821_/X _1822_/X _1827_/Y _1562_/B VGND VGND VDPWR VDPWR _1828_/Y sky130_fd_sc_hd__a211oi_1
X_1759_ _1795_/A _1339_/Y _1758_/Y VGND VGND VDPWR VDPWR _1759_/X sky130_fd_sc_hd__o21ba_1
XFILLER_57_177 VGND VGND VDPWR VDPWR sky130_fd_sc_hd__decap_3
XFILLER_70_34 VGND VGND VDPWR VDPWR sky130_fd_sc_hd__decap_3
XFILLER_70_67 VGND VGND VDPWR VDPWR sky130_fd_sc_hd__fill_1
XFILLER_9_229 VGND VGND VDPWR VDPWR sky130_fd_sc_hd__decap_3
XFILLER_48_111 VGND VGND VDPWR VDPWR sky130_fd_sc_hd__fill_1
XFILLER_71_180 VGND VGND VDPWR VDPWR sky130_fd_sc_hd__decap_3
X_1613_ _1839_/A _1613_/B _1613_/C VGND VGND VDPWR VDPWR _1615_/A sky130_fd_sc_hd__nand3_1
X_1544_ _1544_/A _1544_/B VGND VGND VDPWR VDPWR _1548_/B sky130_fd_sc_hd__or2_1
XFILLER_39_122 VGND VGND VDPWR VDPWR sky130_fd_sc_hd__fill_1
XFILLER_39_177 VGND VGND VDPWR VDPWR sky130_fd_sc_hd__decap_3
X_1475_ _1475_/A VGND VGND VDPWR VDPWR _1487_/B sky130_fd_sc_hd__inv_1
XFILLER_54_169 VGND VGND VDPWR VDPWR sky130_fd_sc_hd__fill_1
X_2027_ _2027_/A _2027_/B _2039_/B VGND VGND VDPWR VDPWR _2140_/D sky130_fd_sc_hd__nor3b_1
XFILLER_49_35 VGND VGND VDPWR VDPWR sky130_fd_sc_hd__decap_3
Xu_adc VDPWR VGND u_adc/clk _1556_/A0 _1556_/A1 _2236_/A _2238_/A _1908_/B _1729_/A
+ _1676_/B _1657_/A1 wire84/X _1676_/B _1667_/A1 _1424_/Y _1426_/Y u_adc/s_axi_bresp[0]
+ u_adc/s_axi_bresp[1] _1390_/B2 _1630_/A1 _1809_/A2 _1846_/A1 _1786_/A2 _1630_/A0
+ _1808_/A1 _1846_/A0 _1784_/A1 _1429_/X u_adc/s_axi_rresp[0] u_adc/s_axi_rresp[1]
+ _1390_/A2 wire70/X u_adc/s_axi_wready u_adc_19/HI _1425_/Y _2239_/A _2237_/A _2162_/Q
+ ua[0] top
XFILLER_45_103 VGND VGND VDPWR VDPWR sky130_fd_sc_hd__decap_3
XFILLER_45_136 VGND VGND VDPWR VDPWR sky130_fd_sc_hd__decap_3
XFILLER_65_12 VGND VGND VDPWR VDPWR sky130_fd_sc_hd__decap_3
X_1260_ _1301_/A _1260_/B VGND VGND VDPWR VDPWR _1260_/Y sky130_fd_sc_hd__nand2_1
X_1191_ _1570_/A _2077_/Q _1191_/C VGND VGND VDPWR VDPWR _1191_/Y sky130_fd_sc_hd__nor3_1
X_1527_ _1531_/A _1527_/B VGND VGND VDPWR VDPWR _1551_/A sky130_fd_sc_hd__nand2_1
XFILLER_59_239 VGND VGND VDPWR VDPWR sky130_fd_sc_hd__fill_2
Xu_sub.u_core.u_regfile.g_nibsel\[3\].g_nib\[3\].u_m2 u_sub.u_core.u_regfile.g_nibsel\[3\].g_nib\[3\].u_lo/X
+ u_sub.u_core.u_regfile.g_nibsel\[3\].g_nib\[3\].u_hi/X max_cap1/X VGND VGND VDPWR
+ VDPWR u_sub.u_core.u_regfile.g_port\[3\].u_b/A2 sky130_fd_sc_hd__mux2_1
X_1458_ _1747_/A _1458_/B VGND VGND VDPWR VDPWR _1458_/Y sky130_fd_sc_hd__nand2b_1
X_1389_ _1723_/C _1720_/A VGND VGND VDPWR VDPWR _1389_/Y sky130_fd_sc_hd__nor2_1
XFILLER_50_172 VGND VGND VDPWR VDPWR sky130_fd_sc_hd__decap_3
XFILLER_50_194 VGND VGND VDPWR VDPWR sky130_fd_sc_hd__decap_3
XFILLER_2_235 VGND VGND VDPWR VDPWR sky130_fd_sc_hd__fill_1
XTAP_TAPCELL_ROW_14_2_2_142 VGND VDPWR sky130_fd_sc_hd__tapvpwrvgnd_1
XFILLER_37_4 VGND VGND VDPWR VDPWR sky130_fd_sc_hd__decap_3
XPHY_EDGE_ROW_47_Left_106 VGND VDPWR sky130_fd_sc_hd__tapvpwrvgnd_1
XPHY_EDGE_ROW_56_Left_115 VGND VDPWR sky130_fd_sc_hd__tapvpwrvgnd_1
X_1312_ _1312_/A _1312_/B VGND VGND VDPWR VDPWR _1312_/Y sky130_fd_sc_hd__nand2_1
X_1243_ _1151_/B _1241_/Y _1242_/Y VGND VGND VDPWR VDPWR _1243_/Y sky130_fd_sc_hd__o21ai_1
X_1174_ _1174_/A _1174_/B _1174_/C VGND VGND VDPWR VDPWR _1235_/B sky130_fd_sc_hd__nor3_1
XANTENNA_13 _1534_/C VGND VGND VDPWR VDPWR sky130_fd_sc_hd__diode_2
XFILLER_17_191 VGND VGND VDPWR VDPWR sky130_fd_sc_hd__fill_1
XPHY_EDGE_ROW_65_Left_124 VGND VDPWR sky130_fd_sc_hd__tapvpwrvgnd_1
Xclkbuf_1_1__f_u_sub.u_core.addr_gclk clkbuf_0_u_sub.u_core.addr_gclk/X VGND VGND
+ VDPWR VDPWR _2194_/CLK sky130_fd_sc_hd__clkbuf_2
XPHY_EDGE_ROW_74_Left_133 VGND VDPWR sky130_fd_sc_hd__tapvpwrvgnd_1
Xmax_cap15 hold21/X VGND VGND VDPWR VDPWR _2039_/B sky130_fd_sc_hd__buf_12
Xu_sub.u_core.u_cg_wb_hi.u_icg clkload2/A _1415_/Y VGND VGND VDPWR VDPWR u_sub.u_core.u_cg_wb_hi.u_icg/GCLK
+ sky130_fd_sc_hd__dlclkp_1
XFILLER_23_194 VGND VGND VDPWR VDPWR sky130_fd_sc_hd__fill_2
X_1930_ _1930_/A _1931_/B VGND VGND VDPWR VDPWR _1936_/B sky130_fd_sc_hd__nand2_1
XFILLER_14_194 VGND VGND VDPWR VDPWR sky130_fd_sc_hd__decap_3
X_1861_ _1861_/A _1861_/B VGND VGND VDPWR VDPWR _1861_/Y sky130_fd_sc_hd__nand2_1
X_1792_ _2091_/Q _1792_/B _1792_/C VGND VGND VDPWR VDPWR _1792_/Y sky130_fd_sc_hd__nor3_1
XFILLER_35_1 VGND VGND VDPWR VDPWR sky130_fd_sc_hd__decap_3
Xclkbuf_1_0__f_clk delaybuf_20_clk/X VGND VGND VDPWR VDPWR clkbuf_leaf_7_clk/A sky130_fd_sc_hd__clkbuf_2
XFILLER_37_242 VGND VGND VDPWR VDPWR sky130_fd_sc_hd__decap_3
XTAP_TAPCELL_ROW_54_229 VGND VDPWR sky130_fd_sc_hd__tapvpwrvgnd_1
X_1226_ _1202_/Y _1210_/B _1201_/Y VGND VGND VDPWR VDPWR _1257_/A sky130_fd_sc_hd__o21ai_1
X_1157_ _1053_/B _1054_/Y _1076_/C _1498_/A _1148_/Y VGND VGND VDPWR VDPWR _1157_/Y
+ sky130_fd_sc_hd__a221oi_1
XFILLER_32_16 VGND VGND VDPWR VDPWR sky130_fd_sc_hd__decap_3
XFILLER_52_256 VGND VGND VDPWR VDPWR sky130_fd_sc_hd__decap_3
X_1088_ _1570_/A _1841_/S VGND VGND VDPWR VDPWR _1324_/A sky130_fd_sc_hd__nor2_1
XFILLER_57_35 VGND VGND VDPWR VDPWR sky130_fd_sc_hd__decap_3
XFILLER_43_201 VGND VGND VDPWR VDPWR sky130_fd_sc_hd__decap_3
XFILLER_43_278 VGND VGND VDPWR VDPWR sky130_fd_sc_hd__decap_3
XFILLER_43_289 VGND VGND VDPWR VDPWR sky130_fd_sc_hd__fill_1
Xwire90 wire90/A VGND VGND VDPWR VDPWR wire90/X sky130_fd_sc_hd__buf_2
XFILLER_34_212 VGND VGND VDPWR VDPWR sky130_fd_sc_hd__fill_1
X_1011_ _2080_/Q VGND VGND VDPWR VDPWR _1011_/Y sky130_fd_sc_hd__inv_1
X_2060_ clkload6/A _2060_/D VGND VGND VDPWR VDPWR hold22/A sky130_fd_sc_hd__dfxtp_1
XFILLER_34_245 VGND VGND VDPWR VDPWR sky130_fd_sc_hd__fill_2
XFILLER_34_289 VGND VGND VDPWR VDPWR sky130_fd_sc_hd__fill_1
X_1913_ _1487_/C _1911_/Y _1912_/Y VGND VGND VDPWR VDPWR _2117_/D sky130_fd_sc_hd__a21oi_1
X_1844_ _2147_/Q _1844_/B VGND VGND VDPWR VDPWR _1844_/Y sky130_fd_sc_hd__nand2_1
X_1775_ _1841_/S _1775_/B VGND VGND VDPWR VDPWR _1779_/S sky130_fd_sc_hd__nor2_1
XFILLER_25_234 VGND VGND VDPWR VDPWR sky130_fd_sc_hd__fill_2
X_2189_ _2193_/CLK hold38/X VGND VGND VDPWR VDPWR hold45/A sky130_fd_sc_hd__dfxtp_1
X_1209_ _1209_/A VGND VGND VDPWR VDPWR _1210_/B sky130_fd_sc_hd__inv_1
XTAP_TAPCELL_ROW_50_210 VGND VDPWR sky130_fd_sc_hd__tapvpwrvgnd_1
XFILLER_68_56 VGND VGND VDPWR VDPWR sky130_fd_sc_hd__fill_1
XTAP_TAPCELL_ROW_73_324 VGND VDPWR sky130_fd_sc_hd__tapvpwrvgnd_1
XFILLER_33_81 VGND VGND VDPWR VDPWR sky130_fd_sc_hd__fill_1
XFILLER_69_7 VGND VGND VDPWR VDPWR sky130_fd_sc_hd__decap_3
XPHY_EDGE_ROW_39_2_2_Right_58 VGND VDPWR sky130_fd_sc_hd__tapvpwrvgnd_1
X_1560_ _1560_/A _1560_/B VGND VGND VDPWR VDPWR _1564_/A sky130_fd_sc_hd__xnor2_1
X_2112_ _2151_/CLK _2112_/D VGND VGND VDPWR VDPWR _2112_/Q sky130_fd_sc_hd__dfxtp_1
X_1491_ _1487_/Y _1488_/X _1489_/Y _1490_/Y VGND VGND VDPWR VDPWR _2157_/D sky130_fd_sc_hd__o211ai_1
XFILLER_66_167 VGND VGND VDPWR VDPWR sky130_fd_sc_hd__fill_2
X_2043_ wire70/X _2043_/B _2158_/Q _2043_/D VGND VGND VDPWR VDPWR _2044_/C sky130_fd_sc_hd__nand4_1
X_1827_ _1827_/A _1827_/B _1827_/C _1827_/D VGND VGND VDPWR VDPWR _1827_/Y sky130_fd_sc_hd__nor4_1
X_1758_ _1339_/A _1339_/B _1757_/X VGND VGND VDPWR VDPWR _1758_/Y sky130_fd_sc_hd__o21ai_1
X_1689_ _2065_/Q _2066_/Q _2063_/Q _2064_/Q VGND VGND VDPWR VDPWR _1690_/C sky130_fd_sc_hd__nand4b_1
XFILLER_57_156 VGND VGND VDPWR VDPWR sky130_fd_sc_hd__decap_3
XFILLER_57_167 VGND VGND VDPWR VDPWR sky130_fd_sc_hd__decap_3
XFILLER_13_204 VGND VGND VDPWR VDPWR sky130_fd_sc_hd__decap_3
XFILLER_70_13 VGND VGND VDPWR VDPWR sky130_fd_sc_hd__decap_3
XFILLER_70_46 VGND VGND VDPWR VDPWR sky130_fd_sc_hd__decap_3
Xdelaybuf_18_clk delaybuf_18_clk/A VGND VGND VDPWR VDPWR delaybuf_19_clk/A sky130_fd_sc_hd__clkbuf_2
XFILLER_48_156 VGND VGND VDPWR VDPWR sky130_fd_sc_hd__decap_3
XFILLER_63_115 VGND VGND VDPWR VDPWR sky130_fd_sc_hd__decap_3
XFILLER_67_4 VGND VGND VDPWR VDPWR sky130_fd_sc_hd__decap_3
X_1612_ _1827_/C _1610_/Y _1595_/Y VGND VGND VDPWR VDPWR _1612_/Y sky130_fd_sc_hd__a21oi_1
X_1543_ _1553_/A _1543_/B VGND VGND VDPWR VDPWR _1543_/Y sky130_fd_sc_hd__nor2_1
X_1474_ _2151_/Q _2079_/Q VGND VGND VDPWR VDPWR _1475_/A sky130_fd_sc_hd__nand2_1
XFILLER_54_104 VGND VGND VDPWR VDPWR sky130_fd_sc_hd__decap_3
XFILLER_10_207 VGND VGND VDPWR VDPWR sky130_fd_sc_hd__decap_3
X_2026_ _2138_/Q _2139_/Q _2140_/Q VGND VGND VDPWR VDPWR _2027_/B sky130_fd_sc_hd__a21oi_1
XFILLER_10_229 VGND VGND VDPWR VDPWR sky130_fd_sc_hd__fill_2
XFILLER_45_148 VGND VGND VDPWR VDPWR sky130_fd_sc_hd__decap_3
XFILLER_65_35 VGND VGND VDPWR VDPWR sky130_fd_sc_hd__decap_3
XFILLER_53_192 VGND VGND VDPWR VDPWR sky130_fd_sc_hd__fill_2
XFILLER_60_129 VGND VGND VDPWR VDPWR sky130_fd_sc_hd__decap_3
Xu_sub.u_core.u_regfile.g_nibsel\[4\].g_nib\[1\].u_m2 u_sub.u_core.u_regfile.g_nibsel\[4\].g_nib\[1\].u_lo/X
+ u_sub.u_core.u_regfile.g_nibsel\[4\].g_nib\[1\].u_hi/X max_cap1/X VGND VGND VDPWR
+ VDPWR u_sub.u_core.u_regfile.g_port\[1\].u_b/A3 sky130_fd_sc_hd__mux2_1
XFILLER_5_211 VGND VGND VDPWR VDPWR sky130_fd_sc_hd__decap_3
XFILLER_5_222 VGND VGND VDPWR VDPWR sky130_fd_sc_hd__fill_2
XFILLER_5_233 VGND VGND VDPWR VDPWR sky130_fd_sc_hd__decap_3
Xu_sub.u_core.u_regfile.g_word\[2\].g_byte\[1\].u_cg.u_icg clkbuf_leaf_0_clk/X _1536_/Y
+ VGND VGND VDPWR VDPWR u_sub.u_core.u_regfile.g_word\[2\].g_byte\[1\].u_lat/GATE
+ sky130_fd_sc_hd__dlclkp_1
X_1190_ _1121_/B _1242_/A _1841_/S VGND VGND VDPWR VDPWR _1191_/C sky130_fd_sc_hd__a21oi_1
XFILLER_36_137 VGND VGND VDPWR VDPWR sky130_fd_sc_hd__fill_2
XFILLER_36_148 VGND VGND VDPWR VDPWR sky130_fd_sc_hd__fill_2
XFILLER_44_192 VGND VGND VDPWR VDPWR sky130_fd_sc_hd__fill_2
XPHY_EDGE_ROW_23_2_2_Right_42 VGND VDPWR sky130_fd_sc_hd__tapvpwrvgnd_1
XTAP_TAPCELL_ROW_46_187 VGND VDPWR sky130_fd_sc_hd__tapvpwrvgnd_1
XFILLER_65_1 VGND VGND VDPWR VDPWR sky130_fd_sc_hd__fill_2
XPHY_EDGE_ROW_15_2_2_Left_4 VGND VDPWR sky130_fd_sc_hd__tapvpwrvgnd_1
X_1526_ _1532_/A _1550_/A VGND VGND VDPWR VDPWR _1526_/Y sky130_fd_sc_hd__nor2_1
X_1457_ _1457_/A _1457_/B VGND VGND VDPWR VDPWR _1462_/B sky130_fd_sc_hd__nor2_1
XFILLER_35_38 VGND VGND VDPWR VDPWR sky130_fd_sc_hd__fill_2
X_1388_ _2054_/Q _2053_/Q VGND VGND VDPWR VDPWR _1720_/A sky130_fd_sc_hd__nand2_1
X_2009_ _2136_/Q _2021_/A1 _2039_/B VGND VGND VDPWR VDPWR _2009_/Y sky130_fd_sc_hd__o21ai_1
XFILLER_2_225 VGND VGND VDPWR VDPWR sky130_fd_sc_hd__decap_3
XFILLER_41_151 VGND VGND VDPWR VDPWR sky130_fd_sc_hd__decap_3
XFILLER_41_92 VGND VGND VDPWR VDPWR sky130_fd_sc_hd__decap_3
X_1311_ hold65/A _1021_/Y _1311_/B1 hold63/A _1744_/B hold66/A VGND VGND VDPWR VDPWR
+ _1312_/B sky130_fd_sc_hd__a222oi_1
XFILLER_49_273 VGND VGND VDPWR VDPWR sky130_fd_sc_hd__decap_3
XFILLER_64_221 VGND VGND VDPWR VDPWR sky130_fd_sc_hd__fill_2
X_1242_ _1242_/A _1242_/B VGND VGND VDPWR VDPWR _1242_/Y sky130_fd_sc_hd__nand2_1
X_1173_ _1174_/B _1174_/C VGND VGND VDPWR VDPWR _1173_/Y sky130_fd_sc_hd__nor2_1
XANTENNA_14 clk VGND VGND VDPWR VDPWR sky130_fd_sc_hd__diode_2
XFILLER_64_298 VGND VGND VDPWR VDPWR sky130_fd_sc_hd__fill_1
X_1509_ _1584_/C _1560_/A _1839_/A VGND VGND VDPWR VDPWR _1510_/B sky130_fd_sc_hd__o21ai_1
XTAP_TAPCELL_ROW_65_282 VGND VDPWR sky130_fd_sc_hd__tapvpwrvgnd_1
Xmax_cap16 _2075_/Q VGND VGND VDPWR VDPWR _1841_/S sky130_fd_sc_hd__buf_12
XTAP_TAPCELL_ROW_18_2_2_144 VGND VDPWR sky130_fd_sc_hd__tapvpwrvgnd_1
X_1860_ _1839_/A _1854_/Y _1857_/Y _1859_/Y VGND VGND VDPWR VDPWR _2096_/D sky130_fd_sc_hd__a31oi_1
X_1791_ _1791_/A _1791_/B wire73/A VGND VGND VDPWR VDPWR _1792_/C sky130_fd_sc_hd__and3_1
XTAP_TAPCELL_ROW_79_352 VGND VDPWR sky130_fd_sc_hd__tapvpwrvgnd_1
XFILLER_37_287 VGND VGND VDPWR VDPWR sky130_fd_sc_hd__fill_2
X_1225_ hold67/X wire89/X VGND VGND VDPWR VDPWR _1225_/Y sky130_fd_sc_hd__nand2_1
X_1156_ _1114_/X _1144_/Y _1146_/X _1150_/Y VGND VGND VDPWR VDPWR _1160_/B sky130_fd_sc_hd__o31ai_1
X_1087_ _1104_/A _1567_/B _1086_/X _1747_/A VGND VGND VDPWR VDPWR _1087_/Y sky130_fd_sc_hd__a211oi_1
XFILLER_32_28 VGND VGND VDPWR VDPWR sky130_fd_sc_hd__decap_3
X_1989_ _2131_/Q _2021_/A1 _2039_/B VGND VGND VDPWR VDPWR _1989_/Y sky130_fd_sc_hd__o21ai_1
XFILLER_43_246 VGND VGND VDPWR VDPWR sky130_fd_sc_hd__decap_3
Xwire80 wire81/X VGND VGND VDPWR VDPWR wire80/X sky130_fd_sc_hd__buf_1
XFILLER_34_202 VGND VGND VDPWR VDPWR sky130_fd_sc_hd__fill_2
X_1010_ _1034_/A VGND VGND VDPWR VDPWR _1010_/Y sky130_fd_sc_hd__inv_1
Xu_sub.u_core.u_regfile.g_word\[3\].g_byte\[0\].u_lat max_cap120/X max_cap118/X wire116/A
+ max_cap114/X wire112/A max_cap111/X max_cap108/X max_cap106/X u_sub.u_core.u_regfile.g_word\[3\].g_byte\[0\].u_lat/GATE
+ VGND VDPWR u_sub.u_core.u_regfile.g_word\[3\].g_byte\[0\].u_lat/Q0 u_sub.u_core.u_regfile.g_word\[3\].g_byte\[0\].u_lat/Q1
+ u_sub.u_core.u_regfile.g_word\[3\].g_byte\[0\].u_lat/Q2 u_sub.u_core.u_regfile.g_word\[3\].g_byte\[0\].u_lat/Q3
+ u_sub.u_core.u_regfile.g_word\[3\].g_byte\[0\].u_lat/Q4 u_sub.u_core.u_regfile.g_word\[3\].g_byte\[0\].u_lat/Q5
+ u_sub.u_core.u_regfile.g_word\[3\].g_byte\[0\].u_lat/Q6 u_sub.u_core.u_regfile.g_word\[3\].g_byte\[0\].u_lat/Q7
+ dlxtp8_x1
XFILLER_42_290 VGND VGND VDPWR VDPWR sky130_fd_sc_hd__decap_3
X_1912_ _2117_/Q _1487_/C _2044_/A VGND VGND VDPWR VDPWR _1912_/Y sky130_fd_sc_hd__o21ai_1
X_1843_ _2114_/Q _1624_/A _1588_/B _2147_/Q VGND VGND VDPWR VDPWR _1843_/Y sky130_fd_sc_hd__a22oi_1
Xclkbuf_leaf_6_clk delaybuf_16_clk/A VGND VGND VDPWR VDPWR u_adc/clk sky130_fd_sc_hd__clkbuf_2
X_1774_ wire70/X hold149/X _1774_/S VGND VGND VDPWR VDPWR _2086_/D sky130_fd_sc_hd__mux2_1
X_1208_ _1331_/A _1753_/B _1207_/Y VGND VGND VDPWR VDPWR _1209_/A sky130_fd_sc_hd__a21oi_1
XFILLER_40_205 VGND VGND VDPWR VDPWR sky130_fd_sc_hd__fill_2
XFILLER_43_38 VGND VGND VDPWR VDPWR sky130_fd_sc_hd__fill_1
XTAP_TAPCELL_ROW_50_211 VGND VDPWR sky130_fd_sc_hd__tapvpwrvgnd_1
X_2188_ _2193_/CLK hold52/X VGND VGND VDPWR VDPWR hold43/A sky130_fd_sc_hd__dfxtp_1
X_1139_ _1139_/A _1280_/B _1139_/C _1139_/D VGND VGND VDPWR VDPWR _1160_/A sky130_fd_sc_hd__nor4_1
XFILLER_68_13 VGND VGND VDPWR VDPWR sky130_fd_sc_hd__decap_3
XFILLER_48_338 VGND VGND VDPWR VDPWR sky130_fd_sc_hd__fill_2
XFILLER_71_341 VGND VGND VDPWR VDPWR sky130_fd_sc_hd__decap_3
XTAP_TAPCELL_ROW_73_325 VGND VDPWR sky130_fd_sc_hd__tapvpwrvgnd_1
X_1490_ _1352_/X _1403_/X _1504_/B _1486_/Y VGND VGND VDPWR VDPWR _1490_/Y sky130_fd_sc_hd__a22oi_1
XFILLER_66_102 VGND VGND VDPWR VDPWR sky130_fd_sc_hd__fill_2
Xu_sub.u_core.u_regfile.g_nibsel\[4\].g_nib\[3\].u_hi u_sub.u_core.u_regfile.g_word\[4\].g_byte\[2\].u_lat/Q3
+ u_sub.u_core.u_regfile.g_word\[4\].g_byte\[2\].u_lat/Q7 u_sub.u_core.u_regfile.g_word\[4\].g_byte\[3\].u_lat/Q3
+ u_sub.u_core.u_regfile.g_word\[4\].g_byte\[3\].u_lat/Q7 max_cap5/X max_cap3/X VGND
+ VGND VDPWR VDPWR u_sub.u_core.u_regfile.g_nibsel\[4\].g_nib\[3\].u_hi/X tg_mux4_x1
X_2111_ clkload5/A _2111_/D VGND VGND VDPWR VDPWR _2111_/Q sky130_fd_sc_hd__dfxtp_1
X_2042_ _2235_/A _2042_/B VGND VGND VDPWR VDPWR _2044_/B sky130_fd_sc_hd__nand2_1
XFILLER_66_179 VGND VGND VDPWR VDPWR sky130_fd_sc_hd__fill_2
X_1826_ _1834_/A _1834_/B VGND VGND VDPWR VDPWR _1827_/D sky130_fd_sc_hd__nand2_1
Xmax_cap120 max_cap121/X VGND VGND VDPWR VDPWR max_cap120/X sky130_fd_sc_hd__clkbuf_8
X_1757_ _1757_/A _1757_/B _1757_/C VGND VGND VDPWR VDPWR _1757_/X sky130_fd_sc_hd__or3_1
X_1688_ _1688_/A _1688_/B VGND VGND VDPWR VDPWR _2058_/D sky130_fd_sc_hd__nor2_1
XFILLER_65_190 VGND VGND VDPWR VDPWR sky130_fd_sc_hd__decap_3
XFILLER_70_25 VGND VGND VDPWR VDPWR sky130_fd_sc_hd__decap_3
XFILLER_70_58 VGND VGND VDPWR VDPWR sky130_fd_sc_hd__decap_3
XFILLER_70_69 VGND VGND VDPWR VDPWR sky130_fd_sc_hd__decap_3
XFILLER_9_209 VGND VGND VDPWR VDPWR sky130_fd_sc_hd__decap_3
XFILLER_48_124 VGND VGND VDPWR VDPWR sky130_fd_sc_hd__fill_2
XFILLER_48_135 VGND VGND VDPWR VDPWR sky130_fd_sc_hd__fill_1
XFILLER_48_168 VGND VGND VDPWR VDPWR sky130_fd_sc_hd__fill_1
XFILLER_44_341 VGND VGND VDPWR VDPWR sky130_fd_sc_hd__decap_3
XFILLER_48_179 VGND VGND VDPWR VDPWR sky130_fd_sc_hd__decap_3
XFILLER_63_127 VGND VGND VDPWR VDPWR sky130_fd_sc_hd__decap_3
XFILLER_71_171 VGND VGND VDPWR VDPWR sky130_fd_sc_hd__decap_3
X_1611_ _2082_/Q _1834_/A VGND VGND VDPWR VDPWR _1611_/Y sky130_fd_sc_hd__nand2_1
XPHY_EDGE_ROW_44_Right_63 VGND VDPWR sky130_fd_sc_hd__tapvpwrvgnd_1
X_1542_ _1552_/A _1543_/B VGND VGND VDPWR VDPWR _1542_/Y sky130_fd_sc_hd__nor2_1
X_1473_ _1487_/C _1472_/X _2079_/Q VGND VGND VDPWR VDPWR _1476_/B sky130_fd_sc_hd__a21boi_1
XFILLER_39_135 VGND VGND VDPWR VDPWR sky130_fd_sc_hd__decap_3
X_2025_ _2138_/Q _2139_/Q _2024_/Y VGND VGND VDPWR VDPWR _2139_/D sky130_fd_sc_hd__a21oi_1
XPHY_EDGE_ROW_53_Right_72 VGND VDPWR sky130_fd_sc_hd__tapvpwrvgnd_1
X_1809_ _1174_/A _1809_/A2 _1429_/D VGND VGND VDPWR VDPWR _1809_/Y sky130_fd_sc_hd__o21ai_1
XPHY_EDGE_ROW_62_Right_81 VGND VDPWR sky130_fd_sc_hd__tapvpwrvgnd_1
XFILLER_45_127 VGND VGND VDPWR VDPWR sky130_fd_sc_hd__decap_3
XFILLER_65_58 VGND VGND VDPWR VDPWR sky130_fd_sc_hd__decap_3
XPHY_EDGE_ROW_71_Right_90 VGND VDPWR sky130_fd_sc_hd__tapvpwrvgnd_1
Xclkbuf_1_1__f_u_sub.u_timer.u_cg_wd.gclk_o clkbuf_0_u_sub.u_timer.u_cg_wd.gclk_o/X
+ VGND VGND VDPWR VDPWR _2213_/CLK sky130_fd_sc_hd__clkbuf_2
XFILLER_51_108 VGND VGND VDPWR VDPWR sky130_fd_sc_hd__fill_1
XFILLER_55_91 VGND VGND VDPWR VDPWR sky130_fd_sc_hd__decap_3
XTAP_TAPCELL_ROW_46_188 VGND VDPWR sky130_fd_sc_hd__tapvpwrvgnd_1
XFILLER_71_90 VGND VGND VDPWR VDPWR sky130_fd_sc_hd__fill_1
XFILLER_67_230 VGND VGND VDPWR VDPWR sky130_fd_sc_hd__fill_1
X_1525_ _1529_/A _1527_/B VGND VGND VDPWR VDPWR _1550_/A sky130_fd_sc_hd__nand2_1
X_1456_ _1744_/B _1449_/Y _1451_/Y _2152_/Q _1455_/Y VGND VGND VDPWR VDPWR _1457_/B
+ sky130_fd_sc_hd__o221ai_1
X_1387_ _1624_/B _2037_/A VGND VGND VDPWR VDPWR _1429_/D sky130_fd_sc_hd__nor2_1
XFILLER_35_171 VGND VGND VDPWR VDPWR sky130_fd_sc_hd__fill_1
X_2008_ _2136_/Q _2008_/B VGND VGND VDPWR VDPWR _2011_/B sky130_fd_sc_hd__xor2_1
XFILLER_51_38 VGND VGND VDPWR VDPWR sky130_fd_sc_hd__fill_2
Xclkbuf_1_1__f_u_sub.u_timer.g_cmp\[1\].g clkbuf_0_u_sub.u_timer.g_cmp\[1\].g/X VGND
+ VGND VDPWR VDPWR _2222_/GATE sky130_fd_sc_hd__clkbuf_2
XFILLER_41_130 VGND VGND VDPWR VDPWR sky130_fd_sc_hd__decap_3
Xu_sub.u_core.u_regfile.g_nibsel\[1\].g_nib\[2\].u_m2 u_sub.u_core.u_regfile.g_nibsel\[1\].g_nib\[2\].u_lo/X
+ u_sub.u_core.u_regfile.g_nibsel\[1\].g_nib\[2\].u_hi/X _1583_/Y VGND VGND VDPWR
+ VDPWR u_sub.u_core.u_regfile.g_port\[2\].u_b/A0 sky130_fd_sc_hd__mux2_1
X_1310_ _2166_/Q _1520_/A VGND VGND VDPWR VDPWR _1312_/A sky130_fd_sc_hd__nand2_1
X_1241_ _1241_/A _1326_/A VGND VGND VDPWR VDPWR _1241_/Y sky130_fd_sc_hd__nand2_1
XFILLER_64_233 VGND VGND VDPWR VDPWR sky130_fd_sc_hd__fill_2
XFILLER_64_255 VGND VGND VDPWR VDPWR sky130_fd_sc_hd__fill_1
X_1172_ _1841_/S _1242_/B VGND VGND VDPWR VDPWR _1172_/Y sky130_fd_sc_hd__nand2_1
XANTENNA_15 _2235_/A VGND VGND VDPWR VDPWR sky130_fd_sc_hd__diode_2
X_1508_ _1593_/A _1593_/B _1757_/B VGND VGND VDPWR VDPWR _1560_/A sky130_fd_sc_hd__nand3_1
X_1439_ _1624_/B _2037_/B VGND VGND VDPWR VDPWR _1441_/A sky130_fd_sc_hd__nand2_1
XTAP_TAPCELL_ROW_65_283 VGND VDPWR sky130_fd_sc_hd__tapvpwrvgnd_1
XFILLER_46_211 VGND VGND VDPWR VDPWR sky130_fd_sc_hd__fill_1
XFILLER_61_203 VGND VGND VDPWR VDPWR sky130_fd_sc_hd__decap_3
X_1790_ _1790_/A _1790_/B _1790_/C wire90/X VGND VGND VDPWR VDPWR _1792_/B sky130_fd_sc_hd__nor4_1
XFILLER_37_222 VGND VGND VDPWR VDPWR sky130_fd_sc_hd__decap_3
XTAP_TAPCELL_ROW_79_353 VGND VDPWR sky130_fd_sc_hd__tapvpwrvgnd_1
X_1224_ _1222_/Y _1223_/Y _1026_/Y VGND VGND VDPWR VDPWR _2175_/D sky130_fd_sc_hd__a21oi_1
XFILLER_52_203 VGND VGND VDPWR VDPWR sky130_fd_sc_hd__fill_1
XFILLER_52_247 VGND VGND VDPWR VDPWR sky130_fd_sc_hd__decap_3
X_1155_ _1137_/A _1498_/C _1137_/C _1123_/B _1034_/A VGND VGND VDPWR VDPWR _1155_/Y
+ sky130_fd_sc_hd__o32ai_1
X_1086_ _1130_/B _1130_/C _1127_/B _1485_/B VGND VGND VDPWR VDPWR _1086_/X sky130_fd_sc_hd__o2bb2a_1
X_1988_ _2131_/Q _1988_/B VGND VGND VDPWR VDPWR _2014_/B sky130_fd_sc_hd__xor2_1
XFILLER_43_236 VGND VGND VDPWR VDPWR sky130_fd_sc_hd__fill_2
Xwire92 wire92/A VGND VGND VDPWR VDPWR wire92/X sky130_fd_sc_hd__clkbuf_2
Xwire81 wire81/A VGND VGND VDPWR VDPWR wire81/X sky130_fd_sc_hd__clkbuf_2
Xwire70 wire70/A VGND VGND VDPWR VDPWR wire70/X sky130_fd_sc_hd__clkbuf_8
XFILLER_11_188 VGND VGND VDPWR VDPWR sky130_fd_sc_hd__decap_3
XFILLER_19_200 VGND VGND VDPWR VDPWR sky130_fd_sc_hd__decap_3
X_1911_ _2147_/Q _2114_/Q _1911_/C VGND VGND VDPWR VDPWR _1911_/Y sky130_fd_sc_hd__nand3_1
X_1842_ _1842_/A _1842_/B VGND VGND VDPWR VDPWR _1842_/Y sky130_fd_sc_hd__nand2_1
X_1773_ _1841_/S _2150_/Q _2156_/Q VGND VGND VDPWR VDPWR _1774_/S sky130_fd_sc_hd__nand3_1
XFILLER_69_177 VGND VGND VDPWR VDPWR sky130_fd_sc_hd__decap_3
XFILLER_69_199 VGND VGND VDPWR VDPWR sky130_fd_sc_hd__fill_1
X_2187_ _2194_/CLK hold48/X VGND VGND VDPWR VDPWR hold40/A sky130_fd_sc_hd__dfxtp_1
X_1207_ _2074_/Q _1753_/B VGND VGND VDPWR VDPWR _1207_/Y sky130_fd_sc_hd__nor2_1
X_1138_ _1584_/A _1138_/B VGND VGND VDPWR VDPWR _1139_/D sky130_fd_sc_hd__nor2_1
X_1069_ _1458_/B _1360_/B _1485_/A _1485_/B VGND VGND VDPWR VDPWR _1410_/A sky130_fd_sc_hd__nor4_1
XFILLER_68_25 VGND VGND VDPWR VDPWR sky130_fd_sc_hd__fill_2
XFILLER_68_47 VGND VGND VDPWR VDPWR sky130_fd_sc_hd__decap_3
XTAP_TAPCELL_ROW_73_326 VGND VDPWR sky130_fd_sc_hd__tapvpwrvgnd_1
XFILLER_33_72 VGND VGND VDPWR VDPWR sky130_fd_sc_hd__decap_3
XFILLER_3_195 VGND VGND VDPWR VDPWR sky130_fd_sc_hd__decap_3
XFILLER_58_91 VGND VGND VDPWR VDPWR sky130_fd_sc_hd__decap_3
XFILLER_66_158 VGND VGND VDPWR VDPWR sky130_fd_sc_hd__fill_2
X_2110_ clkload5/A _2110_/D VGND VGND VDPWR VDPWR _2110_/Q sky130_fd_sc_hd__dfxtp_1
X_2041_ _2043_/B _2158_/Q _2043_/D VGND VGND VDPWR VDPWR _2042_/B sky130_fd_sc_hd__nand3_1
Xmax_cap110 max_cap111/X VGND VGND VDPWR VDPWR max_cap110/X sky130_fd_sc_hd__buf_6
Xmax_cap121 _2093_/Q VGND VGND VDPWR VDPWR max_cap121/X sky130_fd_sc_hd__buf_6
X_1825_ _1827_/A _1827_/C _1825_/C VGND VGND VDPWR VDPWR _1825_/Y sky130_fd_sc_hd__nand3_1
X_1756_ _2078_/Q _1756_/B _1756_/C VGND VGND VDPWR VDPWR wire96/A sky130_fd_sc_hd__nor3_1
X_1687_ _2215_/D _1687_/B VGND VGND VDPWR VDPWR _1688_/B sky130_fd_sc_hd__nor2_1
XFILLER_57_147 VGND VGND VDPWR VDPWR sky130_fd_sc_hd__fill_1
XTAP_TAPCELL_ROW_70_307 VGND VDPWR sky130_fd_sc_hd__tapvpwrvgnd_1
X_2239_ _2239_/A VGND VGND VDPWR VDPWR uo_out[6] sky130_fd_sc_hd__buf_2
XFILLER_70_37 VGND VGND VDPWR VDPWR sky130_fd_sc_hd__decap_3
Xu_sub.u_core.u_regfile.g_ir\[0\].u_lat _2093_/Q _2094_/Q _2095_/Q _2096_/Q _2097_/Q
+ _2098_/Q _2099_/Q max_cap107/X u_sub.u_core.u_regfile.g_ir\[0\].u_lat/GATE VGND
+ VDPWR _1128_/A _1128_/B _1128_/C _1220_/A _1104_/B _1103_/A _1124_/C _1512_/B dlxtp8_x1
XFILLER_44_82 VGND VGND VDPWR VDPWR sky130_fd_sc_hd__decap_3
XFILLER_71_183 VGND VGND VDPWR VDPWR sky130_fd_sc_hd__decap_3
X_1610_ _1827_/A _1823_/B _1609_/Y VGND VGND VDPWR VDPWR _1610_/Y sky130_fd_sc_hd__o21ai_1
XFILLER_69_90 VGND VGND VDPWR VDPWR sky130_fd_sc_hd__fill_1
X_1541_ _1551_/A _1543_/B VGND VGND VDPWR VDPWR _1541_/Y sky130_fd_sc_hd__nor2_1
X_1472_ _1472_/A _1584_/C _1472_/C VGND VGND VDPWR VDPWR _1472_/X sky130_fd_sc_hd__or3_1
XFILLER_39_169 VGND VGND VDPWR VDPWR sky130_fd_sc_hd__fill_1
XFILLER_47_180 VGND VGND VDPWR VDPWR sky130_fd_sc_hd__decap_3
XFILLER_47_191 VGND VGND VDPWR VDPWR sky130_fd_sc_hd__decap_3
XFILLER_54_128 VGND VGND VDPWR VDPWR sky130_fd_sc_hd__fill_2
X_2024_ _2138_/Q _2139_/Q _2039_/B VGND VGND VDPWR VDPWR _2024_/Y sky130_fd_sc_hd__o21ai_1
X_1808_ _1808_/A1 _1429_/D _2075_/Q VGND VGND VDPWR VDPWR _1808_/Y sky130_fd_sc_hd__a21oi_1
X_1739_ _2150_/Q _1487_/B _1482_/B VGND VGND VDPWR VDPWR _1739_/Y sky130_fd_sc_hd__o21ai_1
XFILLER_49_38 VGND VGND VDPWR VDPWR sky130_fd_sc_hd__fill_2
XFILLER_65_15 VGND VGND VDPWR VDPWR sky130_fd_sc_hd__decap_3
XFILLER_38_180 VGND VGND VDPWR VDPWR sky130_fd_sc_hd__decap_3
XFILLER_45_139 VGND VGND VDPWR VDPWR sky130_fd_sc_hd__decap_3
XFILLER_29_191 VGND VGND VDPWR VDPWR sky130_fd_sc_hd__decap_3
XFILLER_55_70 VGND VGND VDPWR VDPWR sky130_fd_sc_hd__fill_1
XFILLER_44_183 VGND VGND VDPWR VDPWR sky130_fd_sc_hd__decap_3
XTAP_TAPCELL_ROW_46_189 VGND VDPWR sky130_fd_sc_hd__tapvpwrvgnd_1
X_1524_ _1524_/A _1524_/B VGND VGND VDPWR VDPWR _1527_/B sky130_fd_sc_hd__nand2_1
Xu_sub.u_core.u_regfile.g_nibsel\[2\].g_nib\[0\].u_m2 u_sub.u_core.u_regfile.g_nibsel\[2\].g_nib\[0\].u_lo/X
+ u_sub.u_core.u_regfile.g_nibsel\[2\].g_nib\[0\].u_hi/X max_cap1/X VGND VGND VDPWR
+ VDPWR u_sub.u_core.u_regfile.g_port\[0\].u_b/A1 sky130_fd_sc_hd__mux2_1
X_1455_ _2078_/Q _1586_/A _1747_/A VGND VGND VDPWR VDPWR _1455_/Y sky130_fd_sc_hd__o21ai_1
X_1386_ wire87/X _1806_/A VGND VGND VDPWR VDPWR _2037_/A sky130_fd_sc_hd__nand2_1
X_2007_ _2021_/A1 _2019_/B _2006_/Y VGND VGND VDPWR VDPWR _2135_/D sky130_fd_sc_hd__a21oi_1
XFILLER_50_175 VGND VGND VDPWR VDPWR sky130_fd_sc_hd__decap_3
XFILLER_50_197 VGND VGND VDPWR VDPWR sky130_fd_sc_hd__fill_2
XFILLER_2_216 VGND VGND VDPWR VDPWR sky130_fd_sc_hd__decap_3
XFILLER_58_220 VGND VGND VDPWR VDPWR sky130_fd_sc_hd__decap_3
XFILLER_58_286 VGND VGND VDPWR VDPWR sky130_fd_sc_hd__fill_2
XFILLER_41_142 VGND VGND VDPWR VDPWR sky130_fd_sc_hd__decap_3
XFILLER_41_83 VGND VGND VDPWR VDPWR sky130_fd_sc_hd__decap_3
XFILLER_37_7 VGND VGND VDPWR VDPWR sky130_fd_sc_hd__decap_3
XFILLER_49_231 VGND VGND VDPWR VDPWR sky130_fd_sc_hd__fill_1
X_1240_ _1234_/Y _1235_/Y _1239_/Y VGND VGND VDPWR VDPWR _1240_/Y sky130_fd_sc_hd__a21oi_1
X_1171_ _1174_/B _1170_/Y _1168_/Y VGND VGND VDPWR VDPWR _1242_/B sky130_fd_sc_hd__a21oi_1
XFILLER_32_120 VGND VGND VDPWR VDPWR sky130_fd_sc_hd__decap_3
XFILLER_64_289 VGND VGND VDPWR VDPWR sky130_fd_sc_hd__fill_1
XANTENNA_16 clkload7/A VGND VGND VDPWR VDPWR sky130_fd_sc_hd__diode_2
XFILLER_70_1 VGND VGND VDPWR VDPWR sky130_fd_sc_hd__decap_3
XTAP_TAPCELL_ROW_42_170 VGND VDPWR sky130_fd_sc_hd__tapvpwrvgnd_1
X_1507_ _1487_/Y _1499_/B _1506_/Y VGND VGND VDPWR VDPWR _2153_/D sky130_fd_sc_hd__o21ai_1
XFILLER_55_201 VGND VGND VDPWR VDPWR sky130_fd_sc_hd__decap_3
X_1438_ hold44/A hold56/A _1959_/A VGND VGND VDPWR VDPWR _2037_/B sky130_fd_sc_hd__mux2_1
X_1369_ hold63/A _1959_/A VGND VGND VDPWR VDPWR _1369_/Y sky130_fd_sc_hd__nand2b_1
XPHY_EDGE_ROW_43_Left_102 VGND VDPWR sky130_fd_sc_hd__tapvpwrvgnd_1
XTAP_TAPCELL_ROW_65_284 VGND VDPWR sky130_fd_sc_hd__tapvpwrvgnd_1
XPHY_EDGE_ROW_52_Left_111 VGND VDPWR sky130_fd_sc_hd__tapvpwrvgnd_1
XFILLER_46_256 VGND VGND VDPWR VDPWR sky130_fd_sc_hd__fill_1
XPHY_EDGE_ROW_14_2_2_Left_3 VGND VDPWR sky130_fd_sc_hd__tapvpwrvgnd_1
XPHY_EDGE_ROW_61_Left_120 VGND VDPWR sky130_fd_sc_hd__tapvpwrvgnd_1
XTAP_TAPCELL_ROW_56_240 VGND VDPWR sky130_fd_sc_hd__tapvpwrvgnd_1
XFILLER_14_197 VGND VGND VDPWR VDPWR sky130_fd_sc_hd__decap_3
XFILLER_35_4 VGND VGND VDPWR VDPWR sky130_fd_sc_hd__decap_3
XFILLER_37_245 VGND VGND VDPWR VDPWR sky130_fd_sc_hd__decap_3
XPHY_EDGE_ROW_35_2_2_Right_54 VGND VDPWR sky130_fd_sc_hd__tapvpwrvgnd_1
XTAP_TAPCELL_ROW_79_354 VGND VDPWR sky130_fd_sc_hd__tapvpwrvgnd_1
X_1223_ _2179_/Q _1276_/B _1221_/B _1652_/S VGND VGND VDPWR VDPWR _1223_/Y sky130_fd_sc_hd__a31oi_1
X_1154_ _1151_/B _1153_/Y _1430_/A VGND VGND VDPWR VDPWR _1154_/Y sky130_fd_sc_hd__o21ai_1
XFILLER_32_19 VGND VGND VDPWR VDPWR sky130_fd_sc_hd__decap_3
XFILLER_52_259 VGND VGND VDPWR VDPWR sky130_fd_sc_hd__decap_3
X_1085_ _1485_/B _1127_/B VGND VGND VDPWR VDPWR _1242_/A sky130_fd_sc_hd__or2_1
X_1987_ _2021_/A1 _1985_/Y _1986_/Y VGND VGND VDPWR VDPWR _2130_/D sky130_fd_sc_hd__a21oi_1
XFILLER_57_38 VGND VGND VDPWR VDPWR sky130_fd_sc_hd__fill_2
Xu_sub.u_core.u_regfile.g_word\[2\].g_byte\[3\].u_lat max_cap120/X max_cap118/X wire116/X
+ max_cap114/X wire112/X max_cap110/X max_cap108/X max_cap106/X u_sub.u_core.u_regfile.g_word\[2\].g_byte\[3\].u_lat/GATE
+ VGND VDPWR u_sub.u_core.u_regfile.g_word\[2\].g_byte\[3\].u_lat/Q0 u_sub.u_core.u_regfile.g_word\[2\].g_byte\[3\].u_lat/Q1
+ u_sub.u_core.u_regfile.g_word\[2\].g_byte\[3\].u_lat/Q2 u_sub.u_core.u_regfile.g_word\[2\].g_byte\[3\].u_lat/Q3
+ u_sub.u_core.u_regfile.g_word\[2\].g_byte\[3\].u_lat/Q4 u_sub.u_core.u_regfile.g_word\[2\].g_byte\[3\].u_lat/Q5
+ u_sub.u_core.u_regfile.g_word\[2\].g_byte\[3\].u_lat/Q6 u_sub.u_core.u_regfile.g_word\[2\].g_byte\[3\].u_lat/Q7
+ dlxtp8_x1
XFILLER_43_204 VGND VGND VDPWR VDPWR sky130_fd_sc_hd__decap_3
Xwire71 wire71/A VGND VGND VDPWR VDPWR wire71/X sky130_fd_sc_hd__clkbuf_2
Xwire93 wire93/A VGND VGND VDPWR VDPWR wire93/X sky130_fd_sc_hd__clkbuf_4
XFILLER_42_270 VGND VGND VDPWR VDPWR sky130_fd_sc_hd__fill_2
X_1910_ _1487_/C _1908_/Y _1909_/Y VGND VGND VDPWR VDPWR _2116_/D sky130_fd_sc_hd__a21oi_1
X_1841_ _2135_/Q _2131_/Q _1841_/S VGND VGND VDPWR VDPWR _1842_/B sky130_fd_sc_hd__mux2_1
X_1772_ _1772_/A _1772_/B VGND VGND VDPWR VDPWR _2085_/D sky130_fd_sc_hd__nor2_1
XFILLER_33_1 VGND VGND VDPWR VDPWR sky130_fd_sc_hd__decap_3
X_2186_ _2194_/CLK hold49/X VGND VGND VDPWR VDPWR hold39/A sky130_fd_sc_hd__dfxtp_1
X_1206_ _2078_/Q _1276_/B VGND VGND VDPWR VDPWR _1753_/B sky130_fd_sc_hd__nor2_1
X_1137_ _1137_/A _1498_/C _1137_/C VGND VGND VDPWR VDPWR _1139_/C sky130_fd_sc_hd__or3_1
XFILLER_33_270 VGND VGND VDPWR VDPWR sky130_fd_sc_hd__fill_2
XFILLER_40_218 VGND VGND VDPWR VDPWR sky130_fd_sc_hd__decap_3
X_1068_ _1376_/B _1360_/B VGND VGND VDPWR VDPWR _1068_/Y sky130_fd_sc_hd__nor2_1
XFILLER_39_307 VGND VGND VDPWR VDPWR sky130_fd_sc_hd__fill_1
Xu_sub.u_core.u_regfile.g_nibsel\[4\].g_nib\[3\].u_lo u_sub.u_core.u_regfile.g_word\[4\].g_byte\[0\].u_lat/Q3
+ u_sub.u_core.u_regfile.g_word\[4\].g_byte\[0\].u_lat/Q7 u_sub.u_core.u_regfile.g_word\[4\].g_byte\[1\].u_lat/Q3
+ u_sub.u_core.u_regfile.g_word\[4\].g_byte\[1\].u_lat/Q7 max_cap5/X max_cap3/X VGND
+ VGND VDPWR VDPWR u_sub.u_core.u_regfile.g_nibsel\[4\].g_nib\[3\].u_lo/X tg_mux4_x1
X_2040_ _1016_/Y _2146_/D _2039_/Y VGND VGND VDPWR VDPWR _2147_/D sky130_fd_sc_hd__o21ai_1
Xmax_cap100 _1445_/Y VGND VGND VDPWR VDPWR _1669_/A sky130_fd_sc_hd__clkbuf_4
Xmax_cap111 _2098_/Q VGND VGND VDPWR VDPWR max_cap111/X sky130_fd_sc_hd__clkbuf_8
Xmax_cap122 _1723_/C VGND VGND VDPWR VDPWR _2038_/A sky130_fd_sc_hd__buf_6
Xmax_cap133 _1034_/A VGND VGND VDPWR VDPWR _1153_/D sky130_fd_sc_hd__clkbuf_2
X_1824_ _2083_/Q _1827_/A _1823_/Y VGND VGND VDPWR VDPWR _1834_/B sky130_fd_sc_hd__o21ai_1
X_1755_ _1011_/Y _1753_/Y _1754_/Y VGND VGND VDPWR VDPWR _2080_/D sky130_fd_sc_hd__a21oi_1
X_1686_ _2058_/Q wire71/X _2044_/A VGND VGND VDPWR VDPWR _1688_/A sky130_fd_sc_hd__o21ai_1
XFILLER_57_159 VGND VGND VDPWR VDPWR sky130_fd_sc_hd__fill_1
X_2238_ _2238_/A VGND VGND VDPWR VDPWR uo_out[5] sky130_fd_sc_hd__buf_2
XFILLER_13_207 VGND VGND VDPWR VDPWR sky130_fd_sc_hd__decap_3
XFILLER_65_181 VGND VGND VDPWR VDPWR sky130_fd_sc_hd__decap_3
XTAP_TAPCELL_ROW_70_308 VGND VDPWR sky130_fd_sc_hd__tapvpwrvgnd_1
X_2169_ _2178_/CLK hold57/X _2039_/B VGND VGND VDPWR VDPWR hold60/A sky130_fd_sc_hd__dfrtp_1
XFILLER_70_16 VGND VGND VDPWR VDPWR sky130_fd_sc_hd__decap_3
XFILLER_70_49 VGND VGND VDPWR VDPWR sky130_fd_sc_hd__decap_3
XTAP_TAPCELL_ROW_41_1_1_160 VGND VDPWR sky130_fd_sc_hd__tapvpwrvgnd_1
Xu_sub.u_core.u_regfile.g_nibsel\[2\].g_nib\[2\].u_hi u_sub.u_core.u_regfile.g_word\[2\].g_byte\[2\].u_lat/Q2
+ u_sub.u_core.u_regfile.g_word\[2\].g_byte\[2\].u_lat/Q6 u_sub.u_core.u_regfile.g_word\[2\].g_byte\[3\].u_lat/Q2
+ u_sub.u_core.u_regfile.g_word\[2\].g_byte\[3\].u_lat/Q6 max_cap4/X max_cap2/X VGND
+ VGND VDPWR VDPWR u_sub.u_core.u_regfile.g_nibsel\[2\].g_nib\[2\].u_hi/X tg_mux4_x1
XFILLER_48_137 VGND VGND VDPWR VDPWR sky130_fd_sc_hd__fill_1
XFILLER_48_159 VGND VGND VDPWR VDPWR sky130_fd_sc_hd__decap_3
XFILLER_63_118 VGND VGND VDPWR VDPWR sky130_fd_sc_hd__decap_3
Xu_sub.u_core.u_cg_pc.u_icg clkload3/A _1417_/Y VGND VGND VDPWR VDPWR u_sub.u_core.u_cg_pc.u_icg/GCLK
+ sky130_fd_sc_hd__dlclkp_1
XFILLER_71_162 VGND VGND VDPWR VDPWR sky130_fd_sc_hd__decap_3
XFILLER_67_7 VGND VGND VDPWR VDPWR sky130_fd_sc_hd__decap_3
XFILLER_8_233 VGND VGND VDPWR VDPWR sky130_fd_sc_hd__decap_3
X_1540_ _1550_/A _1543_/B VGND VGND VDPWR VDPWR _1540_/Y sky130_fd_sc_hd__nor2_1
X_1471_ _2073_/Q _1471_/B VGND VGND VDPWR VDPWR _1472_/C sky130_fd_sc_hd__nor2_1
XFILLER_54_107 VGND VGND VDPWR VDPWR sky130_fd_sc_hd__decap_3
XFILLER_62_162 VGND VGND VDPWR VDPWR sky130_fd_sc_hd__decap_3
XFILLER_62_173 VGND VGND VDPWR VDPWR sky130_fd_sc_hd__fill_1
X_2023_ _2138_/Q _2039_/B VGND VGND VDPWR VDPWR _2138_/D sky130_fd_sc_hd__nor2b_1
X_1807_ wire97/X _1807_/B VGND VGND VDPWR VDPWR _1807_/Y sky130_fd_sc_hd__nand2_1
X_1738_ _1366_/A wire73/X _1480_/Y VGND VGND VDPWR VDPWR _1750_/B sky130_fd_sc_hd__o21ai_1
X_1669_ _1669_/A _1669_/B _1881_/C VGND VGND VDPWR VDPWR _1691_/B sky130_fd_sc_hd__nand3_1
XFILLER_38_170 VGND VGND VDPWR VDPWR sky130_fd_sc_hd__decap_3
XFILLER_45_118 VGND VGND VDPWR VDPWR sky130_fd_sc_hd__decap_3
XFILLER_65_38 VGND VGND VDPWR VDPWR sky130_fd_sc_hd__decap_3
Xu_sub.u_core.u_regfile.g_ir\[0\].u_cg.u_icg clkload1/A _1550_/Y VGND VGND VDPWR VDPWR
+ u_sub.u_core.u_regfile.g_ir\[0\].u_lat/GATE sky130_fd_sc_hd__dlclkp_1
XFILLER_38_192 VGND VGND VDPWR VDPWR sky130_fd_sc_hd__decap_3
XFILLER_39_72 VGND VGND VDPWR VDPWR sky130_fd_sc_hd__fill_2
XFILLER_36_129 VGND VGND VDPWR VDPWR sky130_fd_sc_hd__decap_3
X_1523_ _1524_/A _1524_/B VGND VGND VDPWR VDPWR _1531_/B sky130_fd_sc_hd__and2_1
X_1454_ _1452_/Y _1453_/Y _1747_/A VGND VGND VDPWR VDPWR _1457_/A sky130_fd_sc_hd__a21oi_1
X_1385_ hold42/A hold60/A _2151_/Q VGND VGND VDPWR VDPWR _1806_/A sky130_fd_sc_hd__mux2_1
X_2006_ _2135_/Q _2021_/A1 _2039_/B VGND VGND VDPWR VDPWR _2006_/Y sky130_fd_sc_hd__o21ai_1
Xclkbuf_0_clk_regs clkbuf_regs_0_clk/X VGND VGND VDPWR VDPWR clkbuf_0_clk_regs/X sky130_fd_sc_hd__clkbuf_2
XFILLER_2_228 VGND VGND VDPWR VDPWR sky130_fd_sc_hd__decap_3
XFILLER_41_154 VGND VGND VDPWR VDPWR sky130_fd_sc_hd__decap_3
XFILLER_41_165 VGND VGND VDPWR VDPWR sky130_fd_sc_hd__fill_2
XFILLER_41_176 VGND VGND VDPWR VDPWR sky130_fd_sc_hd__fill_2
XFILLER_41_187 VGND VGND VDPWR VDPWR sky130_fd_sc_hd__fill_2
XFILLER_41_198 VGND VGND VDPWR VDPWR sky130_fd_sc_hd__decap_3
XFILLER_41_62 VGND VGND VDPWR VDPWR sky130_fd_sc_hd__decap_3
XFILLER_41_95 VGND VGND VDPWR VDPWR sky130_fd_sc_hd__decap_3
XFILLER_49_276 VGND VGND VDPWR VDPWR sky130_fd_sc_hd__fill_2
X_1170_ _1169_/A _1278_/B _1169_/C _1567_/C VGND VGND VDPWR VDPWR _1170_/Y sky130_fd_sc_hd__o31ai_1
XFILLER_32_132 VGND VGND VDPWR VDPWR sky130_fd_sc_hd__decap_3
XFILLER_63_1 VGND VGND VDPWR VDPWR sky130_fd_sc_hd__fill_2
XTAP_TAPCELL_ROW_42_171 VGND VDPWR sky130_fd_sc_hd__tapvpwrvgnd_1
X_1506_ _2153_/Q _1506_/B VGND VGND VDPWR VDPWR _1506_/Y sky130_fd_sc_hd__nand2_1
X_1437_ _2118_/D VGND VGND VDPWR VDPWR _1914_/B sky130_fd_sc_hd__inv_1
X_1368_ hold38/A hold55/A _1959_/A VGND VGND VDPWR VDPWR _1368_/X sky130_fd_sc_hd__mux2_1
X_1299_ _1299_/A _1299_/B VGND VGND VDPWR VDPWR _1299_/Y sky130_fd_sc_hd__xnor2_1
XTAP_TAPCELL_ROW_65_285 VGND VDPWR sky130_fd_sc_hd__tapvpwrvgnd_1
XPHY_EDGE_ROW_16_2_2_Right_35 VGND VDPWR sky130_fd_sc_hd__tapvpwrvgnd_1
Xdelaybuf_1_clk delaybuf_1_clk/A VGND VGND VDPWR VDPWR delaybuf_2_clk/A sky130_fd_sc_hd__clkbuf_2
XFILLER_61_227 VGND VGND VDPWR VDPWR sky130_fd_sc_hd__decap_3
XTAP_TAPCELL_ROW_56_241 VGND VDPWR sky130_fd_sc_hd__tapvpwrvgnd_1
XTAP_TAPCELL_ROW_79_355 VGND VDPWR sky130_fd_sc_hd__tapvpwrvgnd_1
Xu_sub.u_core.u_regfile.g_word\[1\].g_byte\[0\].u_cg.u_icg clkbuf_leaf_3_clk/X _1526_/Y
+ VGND VGND VDPWR VDPWR u_sub.u_core.u_regfile.g_word\[1\].g_byte\[0\].u_lat/GATE
+ sky130_fd_sc_hd__dlclkp_1
X_1222_ _2195_/Q _1471_/B _1221_/Y VGND VGND VDPWR VDPWR _1222_/Y sky130_fd_sc_hd__o21ai_1
X_1153_ _1316_/B _1350_/A _1153_/C _1153_/D VGND VGND VDPWR VDPWR _1153_/Y sky130_fd_sc_hd__nand4b_1
X_1084_ _1485_/B _1127_/B VGND VGND VDPWR VDPWR _1278_/B sky130_fd_sc_hd__nor2_1
X_1986_ _2130_/Q _2021_/A1 _2039_/B VGND VGND VDPWR VDPWR _1986_/Y sky130_fd_sc_hd__o21ai_1
XFILLER_9_191 VGND VGND VDPWR VDPWR sky130_fd_sc_hd__decap_3
XFILLER_43_216 VGND VGND VDPWR VDPWR sky130_fd_sc_hd__fill_1
XFILLER_43_249 VGND VGND VDPWR VDPWR sky130_fd_sc_hd__decap_3
XTAP_TAPCELL_ROW_53_222 VGND VDPWR sky130_fd_sc_hd__tapvpwrvgnd_1
Xwire83 wire83/A VGND VGND VDPWR VDPWR wire83/X sky130_fd_sc_hd__buf_4
XFILLER_19_235 VGND VGND VDPWR VDPWR sky130_fd_sc_hd__fill_1
XFILLER_47_83 VGND VGND VDPWR VDPWR sky130_fd_sc_hd__decap_3
XFILLER_42_293 VGND VGND VDPWR VDPWR sky130_fd_sc_hd__fill_1
X_1840_ uio_in[2] wire97/X VGND VGND VDPWR VDPWR _1840_/Y sky130_fd_sc_hd__nor2_1
Xclkbuf_1_1__f_u_sub.u_core.pc_gclk clkbuf_0_u_sub.u_core.pc_gclk/X VGND VGND VDPWR
+ VDPWR _2175_/CLK sky130_fd_sc_hd__clkbuf_2
Xu_sub.u_core.u_cg_addr.u_icg clkload3/A _1419_/Y VGND VGND VDPWR VDPWR u_sub.u_core.u_cg_addr.u_icg/GCLK
+ sky130_fd_sc_hd__dlclkp_1
X_1771_ _1771_/A _1771_/B VGND VGND VDPWR VDPWR _1772_/B sky130_fd_sc_hd__nor2_1
XFILLER_69_135 VGND VGND VDPWR VDPWR sky130_fd_sc_hd__fill_1
X_2185_ _2193_/CLK hold45/X VGND VGND VDPWR VDPWR hold42/A sky130_fd_sc_hd__dfxtp_1
X_1205_ _1791_/A _1442_/A VGND VGND VDPWR VDPWR _1276_/B sky130_fd_sc_hd__nand2_1
X_1136_ _1124_/C _1102_/C _1485_/A VGND VGND VDPWR VDPWR _1137_/C sky130_fd_sc_hd__a21oi_1
X_1067_ _1753_/A _1647_/B VGND VGND VDPWR VDPWR _1757_/A sky130_fd_sc_hd__nand2_1
XPHY_EDGE_ROW_80_Left_139 VGND VDPWR sky130_fd_sc_hd__tapvpwrvgnd_1
X_1969_ _2124_/Q _1914_/B _2125_/Q VGND VGND VDPWR VDPWR _1971_/A sky130_fd_sc_hd__a21oi_1
XFILLER_68_16 VGND VGND VDPWR VDPWR sky130_fd_sc_hd__decap_3
XFILLER_16_216 VGND VGND VDPWR VDPWR sky130_fd_sc_hd__decap_3
XFILLER_71_344 VGND VGND VDPWR VDPWR sky130_fd_sc_hd__fill_1
Xu_sub.u_core.u_regfile.g_nibsel\[3\].g_nib\[0\].u_hi u_sub.u_core.u_regfile.g_word\[3\].g_byte\[2\].u_lat/Q0
+ u_sub.u_core.u_regfile.g_word\[3\].g_byte\[2\].u_lat/Q4 u_sub.u_core.u_regfile.g_word\[3\].g_byte\[3\].u_lat/Q0
+ u_sub.u_core.u_regfile.g_word\[3\].g_byte\[3\].u_lat/Q4 max_cap4/X max_cap2/X VGND
+ VGND VDPWR VDPWR ANTENNA_5/DIODE tg_mux4_x1
X_1823_ _1827_/A _1823_/B VGND VGND VDPWR VDPWR _1823_/Y sky130_fd_sc_hd__nand2_1
Xmax_cap101 _1461_/A VGND VGND VDPWR VDPWR _1814_/A sky130_fd_sc_hd__clkbuf_2
Xmax_cap123 _1442_/A VGND VGND VDPWR VDPWR _1397_/A sky130_fd_sc_hd__buf_4
X_1754_ _1764_/A1 _1054_/Y _1753_/Y _1798_/A VGND VGND VDPWR VDPWR _1754_/Y sky130_fd_sc_hd__a211oi_1
X_1685_ _1685_/A _1685_/B VGND VGND VDPWR VDPWR _2057_/D sky130_fd_sc_hd__nor2_1
X_2237_ _2237_/A VGND VGND VDPWR VDPWR uo_out[4] sky130_fd_sc_hd__buf_2
XFILLER_53_344 VGND VGND VDPWR VDPWR sky130_fd_sc_hd__fill_1
XFILLER_65_171 VGND VGND VDPWR VDPWR sky130_fd_sc_hd__fill_1
XTAP_TAPCELL_ROW_70_309 VGND VDPWR sky130_fd_sc_hd__tapvpwrvgnd_1
X_2168_ _2178_/CLK hold61/X _2044_/A VGND VGND VDPWR VDPWR hold54/A sky130_fd_sc_hd__dfrtp_1
X_2099_ _2099_/CLK _2099_/D VGND VGND VDPWR VDPWR _2099_/Q sky130_fd_sc_hd__dfxtp_1
X_1119_ _1123_/A _1123_/B _1119_/C _1119_/D VGND VGND VDPWR VDPWR _1472_/A sky130_fd_sc_hd__nor4_1
XFILLER_70_28 VGND VGND VDPWR VDPWR sky130_fd_sc_hd__decap_3
XTAP_TAPCELL_ROW_41_1_1_161 VGND VDPWR sky130_fd_sc_hd__tapvpwrvgnd_1
XFILLER_44_344 VGND VGND VDPWR VDPWR sky130_fd_sc_hd__fill_1
XFILLER_12_230 VGND VGND VDPWR VDPWR sky130_fd_sc_hd__decap_3
XFILLER_71_174 VGND VGND VDPWR VDPWR sky130_fd_sc_hd__decap_3
XFILLER_60_94 VGND VGND VDPWR VDPWR sky130_fd_sc_hd__fill_2
X_1470_ _2073_/Q _2080_/Q _2115_/Q VGND VGND VDPWR VDPWR _1487_/C sky130_fd_sc_hd__nand3b_1
XFILLER_39_138 VGND VGND VDPWR VDPWR sky130_fd_sc_hd__decap_3
XFILLER_35_344 VGND VGND VDPWR VDPWR sky130_fd_sc_hd__fill_1
XFILLER_47_171 VGND VGND VDPWR VDPWR sky130_fd_sc_hd__decap_3
XFILLER_50_325 VGND VGND VDPWR VDPWR sky130_fd_sc_hd__fill_1
X_2022_ _2022_/A _2039_/B VGND VGND VDPWR VDPWR _2137_/D sky130_fd_sc_hd__nor2b_1
X_1806_ _1806_/A _1806_/B VGND VGND VDPWR VDPWR _1807_/B sky130_fd_sc_hd__nand2_1
X_1737_ _1861_/B _1735_/Y _1736_/Y VGND VGND VDPWR VDPWR _2074_/D sky130_fd_sc_hd__o21ai_1
X_1668_ _2054_/Q _2053_/Q _1720_/B VGND VGND VDPWR VDPWR _1881_/C sky130_fd_sc_hd__nor3_1
X_1599_ _2091_/Q _1599_/B _1599_/C wire90/X VGND VGND VDPWR VDPWR _1599_/Y sky130_fd_sc_hd__nand4_1
XFILLER_38_160 VGND VGND VDPWR VDPWR sky130_fd_sc_hd__fill_2
Xu_sub.u_core.u_regfile.g_word\[3\].g_byte\[3\].u_cg.u_icg clkbuf_leaf_0_clk/X _1543_/Y
+ VGND VGND VDPWR VDPWR u_sub.u_core.u_regfile.g_word\[3\].g_byte\[3\].u_lat/GATE
+ sky130_fd_sc_hd__dlclkp_1
XFILLER_36_108 VGND VGND VDPWR VDPWR sky130_fd_sc_hd__decap_3
XFILLER_39_51 VGND VGND VDPWR VDPWR sky130_fd_sc_hd__fill_2
XFILLER_39_62 VGND VGND VDPWR VDPWR sky130_fd_sc_hd__fill_1
XFILLER_55_94 VGND VGND VDPWR VDPWR sky130_fd_sc_hd__decap_3
X_1522_ _1747_/A _1522_/B VGND VGND VDPWR VDPWR _1524_/B sky130_fd_sc_hd__xnor2_1
X_1453_ _2076_/Q _2152_/Q _1204_/B _1448_/Y VGND VGND VDPWR VDPWR _1453_/Y sky130_fd_sc_hd__o211ai_1
X_2005_ _2005_/A _2008_/B VGND VGND VDPWR VDPWR _2019_/B sky130_fd_sc_hd__nand2_1
X_1384_ hold41/A hold54/A _1959_/A VGND VGND VDPWR VDPWR _1624_/B sky130_fd_sc_hd__mux2_1
XFILLER_58_211 VGND VGND VDPWR VDPWR sky130_fd_sc_hd__decap_3
XFILLER_41_133 VGND VGND VDPWR VDPWR sky130_fd_sc_hd__fill_1
XFILLER_41_41 VGND VGND VDPWR VDPWR sky130_fd_sc_hd__decap_3
XFILLER_49_222 VGND VGND VDPWR VDPWR sky130_fd_sc_hd__decap_3
XFILLER_64_203 VGND VGND VDPWR VDPWR sky130_fd_sc_hd__fill_1
X_1505_ _1505_/A _1505_/B VGND VGND VDPWR VDPWR _2154_/D sky130_fd_sc_hd__nand2_1
X_1436_ hold20/X _1932_/B hold24/X VGND VGND VDPWR VDPWR _1436_/Y sky130_fd_sc_hd__a21oi_1
X_1367_ _1950_/A hold48/A hold52/A hold50/A VGND VGND VDPWR VDPWR _1371_/A sky130_fd_sc_hd__nand4_1
XFILLER_55_236 VGND VGND VDPWR VDPWR sky130_fd_sc_hd__fill_2
XFILLER_55_269 VGND VGND VDPWR VDPWR sky130_fd_sc_hd__fill_2
XTAP_TAPCELL_ROW_65_286 VGND VDPWR sky130_fd_sc_hd__tapvpwrvgnd_1
X_1298_ _1257_/A _1256_/B _1256_/A VGND VGND VDPWR VDPWR _1299_/B sky130_fd_sc_hd__a21boi_1
XFILLER_23_188 VGND VGND VDPWR VDPWR sky130_fd_sc_hd__decap_3
XFILLER_46_236 VGND VGND VDPWR VDPWR sky130_fd_sc_hd__fill_1
XFILLER_14_188 VGND VGND VDPWR VDPWR sky130_fd_sc_hd__decap_3
XFILLER_61_206 VGND VGND VDPWR VDPWR sky130_fd_sc_hd__decap_3
XTAP_TAPCELL_ROW_79_356 VGND VDPWR sky130_fd_sc_hd__tapvpwrvgnd_1
X_1221_ _1221_/A _1221_/B VGND VGND VDPWR VDPWR _1221_/Y sky130_fd_sc_hd__nor2_1
XFILLER_37_214 VGND VGND VDPWR VDPWR sky130_fd_sc_hd__fill_2
X_1152_ _1153_/D _1039_/Y _1350_/B VGND VGND VDPWR VDPWR _1430_/A sky130_fd_sc_hd__a21oi_1
X_1083_ _1220_/A _1128_/C _1128_/B _1128_/A VGND VGND VDPWR VDPWR _1127_/B sky130_fd_sc_hd__nand4b_1
XTAP_TAPCELL_ROW_62_267 VGND VDPWR sky130_fd_sc_hd__tapvpwrvgnd_1
X_1985_ _2130_/Q _2129_/Q VGND VGND VDPWR VDPWR _1985_/Y sky130_fd_sc_hd__xnor2_1
X_1419_ _1647_/B _1419_/B VGND VGND VDPWR VDPWR _1419_/Y sky130_fd_sc_hd__nand2_1
XTAP_TAPCELL_ROW_53_223 VGND VDPWR sky130_fd_sc_hd__tapvpwrvgnd_1
Xwire95 wire95/A VGND VGND VDPWR VDPWR wire95/X sky130_fd_sc_hd__clkbuf_2
Xwire84 wire84/A VGND VGND VDPWR VDPWR wire84/X sky130_fd_sc_hd__clkbuf_2
Xwire73 wire73/A VGND VGND VDPWR VDPWR wire73/X sky130_fd_sc_hd__clkbuf_2
XFILLER_51_294 VGND VGND VDPWR VDPWR sky130_fd_sc_hd__decap_3
XFILLER_19_203 VGND VGND VDPWR VDPWR sky130_fd_sc_hd__decap_3
XTAP_TAPCELL_ROW_76_337 VGND VDPWR sky130_fd_sc_hd__tapvpwrvgnd_1
XPHY_EDGE_ROW_69_Right_88 VGND VDPWR sky130_fd_sc_hd__tapvpwrvgnd_1
X_1770_ _2085_/Q _1770_/B VGND VGND VDPWR VDPWR _1772_/A sky130_fd_sc_hd__nor2_1
XPHY_EDGE_ROW_78_Right_97 VGND VDPWR sky130_fd_sc_hd__tapvpwrvgnd_1
XFILLER_69_114 VGND VGND VDPWR VDPWR sky130_fd_sc_hd__fill_1
X_2184_ _2193_/CLK hold43/X VGND VGND VDPWR VDPWR hold41/A sky130_fd_sc_hd__dfxtp_1
X_1204_ _1747_/A _1204_/B VGND VGND VDPWR VDPWR _1588_/B sky130_fd_sc_hd__nor2_1
X_1135_ _1513_/A _1534_/B _1544_/A VGND VGND VDPWR VDPWR _1135_/Y sky130_fd_sc_hd__nand3_1
X_1066_ _2153_/Q _1756_/B VGND VGND VDPWR VDPWR _1215_/C sky130_fd_sc_hd__nor2_1
X_1968_ _2124_/Q hold24/A _2118_/D _1939_/B VGND VGND VDPWR VDPWR _2124_/D sky130_fd_sc_hd__o22a_1
X_1899_ _2213_/D _1894_/X _2044_/A VGND VGND VDPWR VDPWR _1900_/B sky130_fd_sc_hd__o21ai_1
XPHY_EDGE_ROW_13_2_2_Left_2 VGND VDPWR sky130_fd_sc_hd__tapvpwrvgnd_1
XFILLER_33_75 VGND VGND VDPWR VDPWR sky130_fd_sc_hd__decap_3
XFILLER_3_198 VGND VGND VDPWR VDPWR sky130_fd_sc_hd__decap_3
X_1822_ _1827_/A _1827_/B _1827_/C VGND VGND VDPWR VDPWR _1822_/X sky130_fd_sc_hd__or3_1
X_1753_ _1753_/A _1753_/B _1753_/C VGND VGND VDPWR VDPWR _1753_/Y sky130_fd_sc_hd__nand3_1
Xmax_cap102 _1092_/Y VGND VGND VDPWR VDPWR _1744_/B sky130_fd_sc_hd__clkbuf_4
Xmax_cap113 _2097_/Q VGND VGND VDPWR VDPWR wire112/A sky130_fd_sc_hd__clkbuf_8
Xmax_cap124 _1174_/A VGND VGND VDPWR VDPWR _1791_/A sky130_fd_sc_hd__buf_6
X_1684_ _2214_/D _1687_/B VGND VGND VDPWR VDPWR _1685_/B sky130_fd_sc_hd__nor2_1
XFILLER_53_323 VGND VGND VDPWR VDPWR sky130_fd_sc_hd__decap_3
X_2236_ _2236_/A VGND VGND VDPWR VDPWR uo_out[3] sky130_fd_sc_hd__buf_2
X_2167_ _2175_/CLK hold58/X _2039_/B VGND VGND VDPWR VDPWR hold56/A sky130_fd_sc_hd__dfrtp_1
XFILLER_21_220 VGND VGND VDPWR VDPWR sky130_fd_sc_hd__fill_1
X_1049_ _1104_/B _1124_/C _1103_/A VGND VGND VDPWR VDPWR _1129_/A sky130_fd_sc_hd__nand3b_1
X_2098_ _2100_/CLK _2098_/D VGND VGND VDPWR VDPWR _2098_/Q sky130_fd_sc_hd__dfxtp_1
X_1118_ _1118_/A _1142_/A _1142_/B _1142_/C VGND VGND VDPWR VDPWR _1119_/D sky130_fd_sc_hd__or4_1
Xu_sub.u_core.u_regfile.g_nibsel\[2\].g_nib\[2\].u_lo u_sub.u_core.u_regfile.g_word\[2\].g_byte\[0\].u_lat/Q2
+ u_sub.u_core.u_regfile.g_word\[2\].g_byte\[0\].u_lat/Q6 u_sub.u_core.u_regfile.g_word\[2\].g_byte\[1\].u_lat/Q2
+ u_sub.u_core.u_regfile.g_word\[2\].g_byte\[1\].u_lat/Q6 max_cap4/X max_cap2/X VGND
+ VGND VDPWR VDPWR u_sub.u_core.u_regfile.g_nibsel\[2\].g_nib\[2\].u_lo/X tg_mux4_x1
XFILLER_56_172 VGND VGND VDPWR VDPWR sky130_fd_sc_hd__fill_2
XFILLER_56_183 VGND VGND VDPWR VDPWR sky130_fd_sc_hd__decap_3
XFILLER_71_153 VGND VGND VDPWR VDPWR sky130_fd_sc_hd__decap_3
XPHY_EDGE_ROW_41_1_1_Right_60 VGND VDPWR sky130_fd_sc_hd__tapvpwrvgnd_1
XFILLER_44_85 VGND VGND VDPWR VDPWR sky130_fd_sc_hd__decap_3
XFILLER_71_186 VGND VGND VDPWR VDPWR sky130_fd_sc_hd__fill_2
XFILLER_35_323 VGND VGND VDPWR VDPWR sky130_fd_sc_hd__fill_1
XFILLER_47_150 VGND VGND VDPWR VDPWR sky130_fd_sc_hd__decap_3
X_2021_ _2021_/A1 _2011_/X _2020_/Y _1555_/B _2137_/Q VGND VGND VDPWR VDPWR _2022_/A
+ sky130_fd_sc_hd__a32oi_1
XFILLER_47_183 VGND VGND VDPWR VDPWR sky130_fd_sc_hd__decap_3
XFILLER_62_120 VGND VGND VDPWR VDPWR sky130_fd_sc_hd__decap_3
XFILLER_62_153 VGND VGND VDPWR VDPWR sky130_fd_sc_hd__decap_3
X_1805_ _1894_/D _1804_/Y _1803_/Y _1802_/Y VGND VGND VDPWR VDPWR _1806_/B sky130_fd_sc_hd__o211ai_1
X_1736_ _1736_/A _1861_/B VGND VGND VDPWR VDPWR _1736_/Y sky130_fd_sc_hd__nand2_1
X_1667_ _1667_/A1 _1423_/Y _1675_/B _1879_/A VGND VGND VDPWR VDPWR _1672_/B sky130_fd_sc_hd__a211o_1
X_1598_ wire90/X VGND VGND VDPWR VDPWR _1598_/Y sky130_fd_sc_hd__inv_1
XFILLER_38_183 VGND VGND VDPWR VDPWR sky130_fd_sc_hd__decap_3
XFILLER_53_175 VGND VGND VDPWR VDPWR sky130_fd_sc_hd__decap_3
XFILLER_65_18 VGND VGND VDPWR VDPWR sky130_fd_sc_hd__fill_2
X_2219_ _2223_/D _2219_/GATE VGND VGND VDPWR VDPWR _2219_/Q sky130_fd_sc_hd__dlxtp_1
XPHY_EDGE_ROW_30_2_2_Left_19 VGND VDPWR sky130_fd_sc_hd__tapvpwrvgnd_1
XFILLER_39_96 VGND VGND VDPWR VDPWR sky130_fd_sc_hd__decap_3
XFILLER_29_194 VGND VGND VDPWR VDPWR sky130_fd_sc_hd__fill_2
XFILLER_71_50 VGND VGND VDPWR VDPWR sky130_fd_sc_hd__decap_3
XFILLER_67_223 VGND VGND VDPWR VDPWR sky130_fd_sc_hd__fill_2
Xdelaybuf_20_clk delaybuf_20_clk/A VGND VGND VDPWR VDPWR delaybuf_20_clk/X sky130_fd_sc_hd__clkbuf_2
X_1521_ _1521_/A _1521_/B VGND VGND VDPWR VDPWR _1522_/B sky130_fd_sc_hd__nand2_1
X_1452_ _1749_/A _1562_/B _2152_/Q VGND VGND VDPWR VDPWR _1452_/Y sky130_fd_sc_hd__o21ai_1
X_1383_ _1366_/A _1366_/B _2038_/A _1392_/B VGND VGND VDPWR VDPWR wire87/A sky130_fd_sc_hd__a31oi_1
XPHY_EDGE_ROW_31_2_2_Right_50 VGND VDPWR sky130_fd_sc_hd__tapvpwrvgnd_1
X_2004_ _2135_/Q _2134_/Q _2004_/C VGND VGND VDPWR VDPWR _2008_/B sky130_fd_sc_hd__nand3_1
XFILLER_50_178 VGND VGND VDPWR VDPWR sky130_fd_sc_hd__fill_2
XFILLER_2_219 VGND VGND VDPWR VDPWR sky130_fd_sc_hd__fill_2
X_1719_ _1719_/A _1719_/B VGND VGND VDPWR VDPWR _2067_/D sky130_fd_sc_hd__nor2_1
XFILLER_58_223 VGND VGND VDPWR VDPWR sky130_fd_sc_hd__decap_3
Xdelaybuf_11_clk delaybuf_11_clk/A VGND VGND VDPWR VDPWR delaybuf_12_clk/A sky130_fd_sc_hd__clkbuf_2
XFILLER_41_101 VGND VGND VDPWR VDPWR sky130_fd_sc_hd__fill_1
XFILLER_41_112 VGND VGND VDPWR VDPWR sky130_fd_sc_hd__fill_1
XFILLER_41_145 VGND VGND VDPWR VDPWR sky130_fd_sc_hd__decap_3
XFILLER_41_31 VGND VGND VDPWR VDPWR sky130_fd_sc_hd__decap_3
XFILLER_41_86 VGND VGND VDPWR VDPWR sky130_fd_sc_hd__decap_3
Xu_sub.u_core.u_regfile.g_word\[1\].g_byte\[2\].u_lat max_cap121/X max_cap119/X wire116/A
+ max_cap115/X wire112/A max_cap111/X max_cap109/X _2100_/Q u_sub.u_core.u_regfile.g_word\[1\].g_byte\[2\].u_lat/GATE
+ VGND VDPWR u_sub.u_core.u_regfile.g_word\[1\].g_byte\[2\].u_lat/Q0 u_sub.u_core.u_regfile.g_word\[1\].g_byte\[2\].u_lat/Q1
+ u_sub.u_core.u_regfile.g_word\[1\].g_byte\[2\].u_lat/Q2 u_sub.u_core.u_regfile.g_word\[1\].g_byte\[2\].u_lat/Q3
+ u_sub.u_core.u_regfile.g_word\[1\].g_byte\[2\].u_lat/Q4 u_sub.u_core.u_regfile.g_word\[1\].g_byte\[2\].u_lat/Q5
+ u_sub.u_core.u_regfile.g_word\[1\].g_byte\[2\].u_lat/Q6 u_sub.u_core.u_regfile.g_word\[1\].g_byte\[2\].u_lat/Q7
+ dlxtp8_x1
XFILLER_32_123 VGND VGND VDPWR VDPWR sky130_fd_sc_hd__decap_3
XFILLER_32_145 VGND VGND VDPWR VDPWR sky130_fd_sc_hd__decap_3
XPHY_EDGE_ROW_50_Right_69 VGND VDPWR sky130_fd_sc_hd__tapvpwrvgnd_1
XTAP_TAPCELL_ROW_42_162 VGND VDPWR sky130_fd_sc_hd__tapvpwrvgnd_1
XFILLER_49_1 VGND VGND VDPWR VDPWR sky130_fd_sc_hd__fill_1
XFILLER_70_4 VGND VGND VDPWR VDPWR sky130_fd_sc_hd__decap_3
X_1504_ _1753_/A _1504_/B wire85/X VGND VGND VDPWR VDPWR _1505_/B sky130_fd_sc_hd__nand3_1
XFILLER_55_204 VGND VGND VDPWR VDPWR sky130_fd_sc_hd__fill_2
XFILLER_55_215 VGND VGND VDPWR VDPWR sky130_fd_sc_hd__fill_1
X_1435_ hold23/X _1435_/B VGND VGND VDPWR VDPWR hold24/A sky130_fd_sc_hd__nor2_1
X_1366_ _1366_/A _1366_/B _2038_/A VGND VGND VDPWR VDPWR _1403_/A sky130_fd_sc_hd__and3_1
XFILLER_55_248 VGND VGND VDPWR VDPWR sky130_fd_sc_hd__fill_1
X_1297_ _1300_/A _1297_/B VGND VGND VDPWR VDPWR _1299_/A sky130_fd_sc_hd__xnor2_1
XFILLER_35_7 VGND VGND VDPWR VDPWR sky130_fd_sc_hd__decap_3
XFILLER_69_307 VGND VGND VDPWR VDPWR sky130_fd_sc_hd__fill_1
X_1220_ _1220_/A _1567_/B _1584_/C VGND VGND VDPWR VDPWR wire89/A sky130_fd_sc_hd__nor3_1
X_1151_ _1153_/D _1151_/B _1316_/B _1153_/C VGND VGND VDPWR VDPWR _1350_/B sky130_fd_sc_hd__nor4b_1
XFILLER_45_281 VGND VGND VDPWR VDPWR sky130_fd_sc_hd__fill_2
XFILLER_60_240 VGND VGND VDPWR VDPWR sky130_fd_sc_hd__fill_2
X_1082_ _1130_/B _1130_/C VGND VGND VDPWR VDPWR _1567_/B sky130_fd_sc_hd__nand2_1
XTAP_TAPCELL_ROW_62_268 VGND VDPWR sky130_fd_sc_hd__tapvpwrvgnd_1
X_1984_ _2130_/Q _2129_/Q VGND VGND VDPWR VDPWR _1988_/B sky130_fd_sc_hd__nand2_1
XFILLER_43_207 VGND VGND VDPWR VDPWR sky130_fd_sc_hd__fill_2
X_1418_ _2043_/B _2157_/Q wire89/X VGND VGND VDPWR VDPWR _1419_/B sky130_fd_sc_hd__nand3_1
X_1349_ _1115_/B _1112_/Y _1431_/B VGND VGND VDPWR VDPWR _1349_/Y sky130_fd_sc_hd__a21boi_1
XFILLER_36_270 VGND VGND VDPWR VDPWR sky130_fd_sc_hd__fill_2
XTAP_TAPCELL_ROW_53_224 VGND VDPWR sky130_fd_sc_hd__tapvpwrvgnd_1
Xwire96 wire96/A VGND VGND VDPWR VDPWR wire96/X sky130_fd_sc_hd__clkbuf_2
Xwire85 wire85/A VGND VGND VDPWR VDPWR wire85/X sky130_fd_sc_hd__clkbuf_2
Xwire74 wire75/X VGND VGND VDPWR VDPWR wire74/X sky130_fd_sc_hd__clkbuf_2
XTAP_TAPCELL_ROW_76_338 VGND VDPWR sky130_fd_sc_hd__tapvpwrvgnd_1
XFILLER_42_273 VGND VGND VDPWR VDPWR sky130_fd_sc_hd__decap_3
XFILLER_33_4 VGND VGND VDPWR VDPWR sky130_fd_sc_hd__fill_2
X_2183_ _2194_/CLK hold40/X VGND VGND VDPWR VDPWR hold44/A sky130_fd_sc_hd__dfxtp_1
X_1203_ _1212_/A _1203_/B VGND VGND VDPWR VDPWR _1210_/A sky130_fd_sc_hd__xnor2_1
X_1134_ _1134_/A _1539_/A _1134_/C VGND VGND VDPWR VDPWR _1544_/A sky130_fd_sc_hd__nand3_1
X_1065_ _2150_/Q _2153_/Q VGND VGND VDPWR VDPWR _1647_/B sky130_fd_sc_hd__nand2_1
X_1967_ _2118_/D _1936_/Y _1966_/Y _1934_/B VGND VGND VDPWR VDPWR _2123_/D sky130_fd_sc_hd__o211ai_1
X_1898_ _2113_/Q _1901_/B VGND VGND VDPWR VDPWR _1900_/A sky130_fd_sc_hd__nor2_1
XPHY_EDGE_ROW_28_2_2_Right_47 VGND VDPWR sky130_fd_sc_hd__tapvpwrvgnd_1
XTAP_TAPCELL_ROW_40_2_2_155 VGND VDPWR sky130_fd_sc_hd__tapvpwrvgnd_1
Xu_sub.u_core.u_regfile.g_nibsel\[3\].g_nib\[0\].u_lo u_sub.u_core.u_regfile.g_word\[3\].g_byte\[0\].u_lat/Q0
+ u_sub.u_core.u_regfile.g_word\[3\].g_byte\[0\].u_lat/Q4 u_sub.u_core.u_regfile.g_word\[3\].g_byte\[1\].u_lat/Q0
+ u_sub.u_core.u_regfile.g_word\[3\].g_byte\[1\].u_lat/Q4 max_cap4/X max_cap3/X VGND
+ VGND VDPWR VDPWR u_sub.u_core.u_regfile.g_nibsel\[3\].g_nib\[0\].u_lo/X tg_mux4_x1
Xmax_cap103 _1241_/A VGND VGND VDPWR VDPWR _1520_/A sky130_fd_sc_hd__clkbuf_4
Xmax_cap114 max_cap115/X VGND VGND VDPWR VDPWR max_cap114/X sky130_fd_sc_hd__clkbuf_8
Xmax_cap125 _2151_/Q VGND VGND VDPWR VDPWR _1959_/A sky130_fd_sc_hd__buf_8
X_1821_ _1594_/X _1818_/Y _1819_/Y _1820_/Y VGND VGND VDPWR VDPWR _1821_/X sky130_fd_sc_hd__o22a_1
X_1752_ _1950_/A _2079_/Q _1401_/Y _1756_/C VGND VGND VDPWR VDPWR _2079_/D sky130_fd_sc_hd__o2bb2ai_1
X_1683_ _2057_/Q wire71/X _2044_/A VGND VGND VDPWR VDPWR _1685_/A sky130_fd_sc_hd__o21ai_1
Xmax_cap136 _1188_/A VGND VGND VDPWR VDPWR _1798_/A sky130_fd_sc_hd__clkbuf_4
XFILLER_65_184 VGND VGND VDPWR VDPWR sky130_fd_sc_hd__decap_3
X_2235_ _2235_/A VGND VGND VDPWR VDPWR uo_out[0] sky130_fd_sc_hd__buf_2
X_2166_ _2175_/CLK hold65/X _2039_/B VGND VGND VDPWR VDPWR _2166_/Q sky130_fd_sc_hd__dfrtp_1
X_2097_ _2099_/CLK _2097_/D VGND VGND VDPWR VDPWR _2097_/Q sky130_fd_sc_hd__dfxtp_1
X_1117_ _1282_/B _1117_/B _1117_/C _1121_/B VGND VGND VDPWR VDPWR _1142_/C sky130_fd_sc_hd__or4_1
XFILLER_70_19 VGND VGND VDPWR VDPWR sky130_fd_sc_hd__decap_3
X_1048_ _1104_/B _1124_/C _1104_/A VGND VGND VDPWR VDPWR _1130_/B sky130_fd_sc_hd__and3b_1
Xclkbuf_1_0__f_u_sub.u_timer.g_cmp\[1\].g clkbuf_0_u_sub.u_timer.g_cmp\[1\].g/X VGND
+ VGND VDPWR VDPWR _2223_/GATE sky130_fd_sc_hd__clkbuf_2
XFILLER_56_140 VGND VGND VDPWR VDPWR sky130_fd_sc_hd__decap_3
Xclkbuf_1_1__f_clk clkbuf_0_clk/X VGND VGND VDPWR VDPWR delaybuf_16_clk/A sky130_fd_sc_hd__clkbuf_2
XFILLER_12_210 VGND VGND VDPWR VDPWR sky130_fd_sc_hd__decap_3
XFILLER_44_75 VGND VGND VDPWR VDPWR sky130_fd_sc_hd__fill_1
XFILLER_71_165 VGND VGND VDPWR VDPWR sky130_fd_sc_hd__decap_3
XFILLER_69_50 VGND VGND VDPWR VDPWR sky130_fd_sc_hd__decap_3
XFILLER_62_132 VGND VGND VDPWR VDPWR sky130_fd_sc_hd__decap_3
XPHY_EDGE_ROW_59_Left_118 VGND VDPWR sky130_fd_sc_hd__tapvpwrvgnd_1
X_2020_ _2020_/A _2020_/B _2020_/C _2020_/D VGND VGND VDPWR VDPWR _2020_/Y sky130_fd_sc_hd__nor4_1
XFILLER_50_338 VGND VGND VDPWR VDPWR sky130_fd_sc_hd__fill_2
XFILLER_62_165 VGND VGND VDPWR VDPWR sky130_fd_sc_hd__decap_3
XPHY_EDGE_ROW_68_Left_127 VGND VDPWR sky130_fd_sc_hd__tapvpwrvgnd_1
X_1804_ _2113_/Q _1624_/A _1588_/B _1908_/B VGND VGND VDPWR VDPWR _1804_/Y sky130_fd_sc_hd__a22oi_1
X_1735_ _1333_/X _1336_/B _1332_/X VGND VGND VDPWR VDPWR _1735_/Y sky130_fd_sc_hd__a21oi_1
X_1666_ _2102_/Q _1669_/A _1666_/C VGND VGND VDPWR VDPWR _1879_/A sky130_fd_sc_hd__nor3_1
X_1597_ _1749_/A _1597_/B VGND VGND VDPWR VDPWR wire90/A sky130_fd_sc_hd__xnor2_1
XFILLER_38_195 VGND VGND VDPWR VDPWR sky130_fd_sc_hd__decap_3
XFILLER_41_305 VGND VGND VDPWR VDPWR sky130_fd_sc_hd__fill_1
XFILLER_53_198 VGND VGND VDPWR VDPWR sky130_fd_sc_hd__decap_3
XPHY_EDGE_ROW_77_Left_136 VGND VDPWR sky130_fd_sc_hd__tapvpwrvgnd_1
X_2218_ _2222_/D _2218_/GATE VGND VGND VDPWR VDPWR _2218_/Q sky130_fd_sc_hd__dlxtp_1
X_2149_ clkload8/A _2149_/D _2044_/A VGND VGND VDPWR VDPWR _2149_/Q sky130_fd_sc_hd__dfstp_2
XFILLER_39_86 VGND VGND VDPWR VDPWR sky130_fd_sc_hd__fill_1
XFILLER_44_121 VGND VGND VDPWR VDPWR sky130_fd_sc_hd__fill_2
XPHY_EDGE_ROW_12_2_2_Right_31 VGND VDPWR sky130_fd_sc_hd__tapvpwrvgnd_1
XFILLER_44_165 VGND VGND VDPWR VDPWR sky130_fd_sc_hd__fill_2
XFILLER_71_62 VGND VGND VDPWR VDPWR sky130_fd_sc_hd__decap_3
XFILLER_71_95 VGND VGND VDPWR VDPWR sky130_fd_sc_hd__decap_3
X_1520_ _1520_/A _1827_/A VGND VGND VDPWR VDPWR _1521_/B sky130_fd_sc_hd__xnor2_1
X_1451_ _1448_/Y _1450_/Y _1747_/A _2078_/Q VGND VGND VDPWR VDPWR _1451_/Y sky130_fd_sc_hd__a211oi_1
X_1382_ _2126_/Q _2125_/Q _2128_/Q _2127_/Q VGND VGND VDPWR VDPWR _1382_/Y sky130_fd_sc_hd__a211oi_1
X_2003_ _2134_/Q _2004_/C _2135_/Q VGND VGND VDPWR VDPWR _2005_/A sky130_fd_sc_hd__a21o_1
XTAP_TAPCELL_ROW_45_182 VGND VDPWR sky130_fd_sc_hd__tapvpwrvgnd_1
X_1718_ wire70/X _1691_/A _1691_/B _1729_/A VGND VGND VDPWR VDPWR _1719_/B sky130_fd_sc_hd__o31ai_1
X_1649_ _2195_/Q _2163_/Q _1652_/S VGND VGND VDPWR VDPWR _2207_/D sky130_fd_sc_hd__mux2_1
XFILLER_58_202 VGND VGND VDPWR VDPWR sky130_fd_sc_hd__fill_2
XFILLER_41_157 VGND VGND VDPWR VDPWR sky130_fd_sc_hd__decap_3
XFILLER_41_65 VGND VGND VDPWR VDPWR sky130_fd_sc_hd__fill_1
XFILLER_41_98 VGND VGND VDPWR VDPWR sky130_fd_sc_hd__decap_3
Xdelaybuf_4_clk clkload2/A VGND VGND VDPWR VDPWR delaybuf_5_clk/A sky130_fd_sc_hd__clkbuf_2
XFILLER_49_213 VGND VGND VDPWR VDPWR sky130_fd_sc_hd__fill_1
XTAP_TAPCELL_ROW_59_252 VGND VDPWR sky130_fd_sc_hd__tapvpwrvgnd_1
XFILLER_32_135 VGND VGND VDPWR VDPWR sky130_fd_sc_hd__fill_1
XTAP_TAPCELL_ROW_42_163 VGND VDPWR sky130_fd_sc_hd__tapvpwrvgnd_1
X_1503_ _2154_/Q _1503_/B VGND VGND VDPWR VDPWR _1505_/A sky130_fd_sc_hd__nand2_1
X_1434_ hold21/A _1434_/B VGND VGND VDPWR VDPWR _1435_/B sky130_fd_sc_hd__nand2_1
X_1365_ _1756_/B _1408_/B _1814_/A VGND VGND VDPWR VDPWR _1791_/B sky130_fd_sc_hd__nor3_1
X_1296_ _1300_/A _1297_/B VGND VGND VDPWR VDPWR _1296_/Y sky130_fd_sc_hd__nand2_1
XFILLER_46_205 VGND VGND VDPWR VDPWR sky130_fd_sc_hd__decap_3
XFILLER_54_282 VGND VGND VDPWR VDPWR sky130_fd_sc_hd__fill_1
X_1150_ _1076_/C _1115_/Y _1119_/D _1149_/Y _1137_/A VGND VGND VDPWR VDPWR _1150_/Y
+ sky130_fd_sc_hd__o41ai_1
XFILLER_45_271 VGND VGND VDPWR VDPWR sky130_fd_sc_hd__fill_1
XFILLER_45_293 VGND VGND VDPWR VDPWR sky130_fd_sc_hd__decap_3
XTAP_TAPCELL_ROW_62_269 VGND VDPWR sky130_fd_sc_hd__tapvpwrvgnd_1
Xu_sub.u_core.u_regfile.g_nibsel\[4\].g_nib\[2\].u_m2 u_sub.u_core.u_regfile.g_nibsel\[4\].g_nib\[2\].u_lo/X
+ u_sub.u_core.u_regfile.g_nibsel\[4\].g_nib\[2\].u_hi/X max_cap1/X VGND VGND VDPWR
+ VDPWR u_sub.u_core.u_regfile.g_port\[2\].u_b/A3 sky130_fd_sc_hd__mux2_1
X_1081_ _1128_/A _1128_/B _1128_/C VGND VGND VDPWR VDPWR _1130_/C sky130_fd_sc_hd__and3_1
XFILLER_61_1 VGND VGND VDPWR VDPWR sky130_fd_sc_hd__fill_2
XFILLER_9_194 VGND VGND VDPWR VDPWR sky130_fd_sc_hd__fill_1
X_1983_ _2129_/Q _2021_/A1 _1982_/Y VGND VGND VDPWR VDPWR _2129_/D sky130_fd_sc_hd__a21oi_1
X_1417_ _1421_/A _1417_/B VGND VGND VDPWR VDPWR _1417_/Y sky130_fd_sc_hd__nand2_1
XFILLER_28_216 VGND VGND VDPWR VDPWR sky130_fd_sc_hd__fill_1
X_1348_ _1348_/A _1348_/B _1348_/C VGND VGND VDPWR VDPWR _1431_/B sky130_fd_sc_hd__nand3_1
X_1279_ _1242_/B _1278_/Y _1173_/Y _1024_/B VGND VGND VDPWR VDPWR _1285_/A sky130_fd_sc_hd__a211oi_1
XTAP_TAPCELL_ROW_53_225 VGND VDPWR sky130_fd_sc_hd__tapvpwrvgnd_1
Xwire97 wire97/A VGND VGND VDPWR VDPWR wire97/X sky130_fd_sc_hd__clkbuf_4
Xwire86 wire87/X VGND VGND VDPWR VDPWR wire86/X sky130_fd_sc_hd__buf_2
Xwire75 wire75/A VGND VGND VDPWR VDPWR wire75/X sky130_fd_sc_hd__clkbuf_2
XTAP_TAPCELL_ROW_76_339 VGND VDPWR sky130_fd_sc_hd__tapvpwrvgnd_1
XFILLER_47_86 VGND VGND VDPWR VDPWR sky130_fd_sc_hd__fill_1
X_2182_ _2194_/CLK hold39/X VGND VGND VDPWR VDPWR _2182_/Q sky130_fd_sc_hd__dfxtp_1
X_1202_ _1212_/A _1202_/B _1202_/C VGND VGND VDPWR VDPWR _1202_/Y sky130_fd_sc_hd__nor3_1
X_1133_ _1512_/B _1134_/A _1134_/C VGND VGND VDPWR VDPWR _1534_/B sky130_fd_sc_hd__nand3b_1
X_1064_ _2150_/Q _2153_/Q VGND VGND VDPWR VDPWR _1646_/S sky130_fd_sc_hd__and2_1
X_1966_ _2230_/A hold23/A hold21/A _1966_/D VGND VGND VDPWR VDPWR _1966_/Y sky130_fd_sc_hd__nand4_1
X_1897_ _1897_/A _1897_/B VGND VGND VDPWR VDPWR _2112_/D sky130_fd_sc_hd__nor2_1
XFILLER_68_19 VGND VGND VDPWR VDPWR sky130_fd_sc_hd__decap_3
XFILLER_16_219 VGND VGND VDPWR VDPWR sky130_fd_sc_hd__fill_1
XFILLER_56_333 VGND VGND VDPWR VDPWR sky130_fd_sc_hd__fill_2
XFILLER_68_193 VGND VGND VDPWR VDPWR sky130_fd_sc_hd__fill_2
XFILLER_47_311 VGND VGND VDPWR VDPWR sky130_fd_sc_hd__fill_2
XTAP_TAPCELL_ROW_72_320 VGND VDPWR sky130_fd_sc_hd__tapvpwrvgnd_1
X_1820_ _1827_/C _1610_/Y _1594_/X VGND VGND VDPWR VDPWR _1820_/Y sky130_fd_sc_hd__o21ai_1
Xmax_cap104 _1324_/A VGND VGND VDPWR VDPWR _1311_/B1 sky130_fd_sc_hd__buf_2
Xmax_cap115 _2096_/Q VGND VGND VDPWR VDPWR max_cap115/X sky130_fd_sc_hd__buf_6
Xmax_cap126 _2150_/Q VGND VGND VDPWR VDPWR _2043_/B sky130_fd_sc_hd__buf_6
X_1751_ _1482_/B _1750_/B _1749_/Y _1750_/Y VGND VGND VDPWR VDPWR _2078_/D sky130_fd_sc_hd__o31ai_1
X_1682_ _1682_/A _1682_/B VGND VGND VDPWR VDPWR _2056_/D sky130_fd_sc_hd__nor2_1
X_2234_ _2234_/A VGND VGND VDPWR VDPWR uio_out[5] sky130_fd_sc_hd__buf_2
XFILLER_65_152 VGND VGND VDPWR VDPWR sky130_fd_sc_hd__fill_2
X_1047_ _1104_/B _1103_/A VGND VGND VDPWR VDPWR _1102_/C sky130_fd_sc_hd__nand2b_1
X_2165_ _2178_/CLK hold60/X _2039_/B VGND VGND VDPWR VDPWR _2165_/Q sky130_fd_sc_hd__dfrtp_1
X_2096_ _2096_/CLK _2096_/D VGND VGND VDPWR VDPWR _2096_/Q sky130_fd_sc_hd__dfxtp_1
X_1116_ _1115_/B _1112_/Y _1114_/X _1010_/Y VGND VGND VDPWR VDPWR _1119_/C sky130_fd_sc_hd__a22oi_1
XFILLER_21_222 VGND VGND VDPWR VDPWR sky130_fd_sc_hd__decap_3
X_1949_ _1959_/A hold57/A VGND VGND VDPWR VDPWR _1951_/B sky130_fd_sc_hd__nand2_1
XFILLER_12_222 VGND VGND VDPWR VDPWR sky130_fd_sc_hd__fill_1
XFILLER_12_233 VGND VGND VDPWR VDPWR sky130_fd_sc_hd__decap_3
XFILLER_44_98 VGND VGND VDPWR VDPWR sky130_fd_sc_hd__fill_1
XFILLER_71_111 VGND VGND VDPWR VDPWR sky130_fd_sc_hd__fill_2
XFILLER_71_177 VGND VGND VDPWR VDPWR sky130_fd_sc_hd__decap_3
XFILLER_39_119 VGND VGND VDPWR VDPWR sky130_fd_sc_hd__decap_3
XFILLER_47_174 VGND VGND VDPWR VDPWR sky130_fd_sc_hd__decap_3
XFILLER_50_306 VGND VGND VDPWR VDPWR sky130_fd_sc_hd__decap_3
XPHY_EDGE_ROW_12_2_2_Left_1 VGND VDPWR sky130_fd_sc_hd__tapvpwrvgnd_1
X_1803_ _2235_/A _1844_/B VGND VGND VDPWR VDPWR _1803_/Y sky130_fd_sc_hd__nand2_1
X_1734_ _2043_/B _2157_/Q _1098_/Y VGND VGND VDPWR VDPWR _1861_/B sky130_fd_sc_hd__a21oi_1
X_1665_ _2068_/Q _1881_/B _1666_/C _1665_/D VGND VGND VDPWR VDPWR _1675_/B sky130_fd_sc_hd__nor4_1
X_1596_ _1581_/A _1579_/Y _1578_/Y VGND VGND VDPWR VDPWR _1597_/B sky130_fd_sc_hd__o21ai_1
XFILLER_38_152 VGND VGND VDPWR VDPWR sky130_fd_sc_hd__decap_3
X_2217_ _2221_/D _2218_/GATE VGND VGND VDPWR VDPWR _2217_/Q sky130_fd_sc_hd__dlxtp_1
XFILLER_53_111 VGND VGND VDPWR VDPWR sky130_fd_sc_hd__decap_3
XFILLER_53_166 VGND VGND VDPWR VDPWR sky130_fd_sc_hd__decap_3
X_2148_ _2151_/CLK _2148_/D VGND VGND VDPWR VDPWR _2235_/A sky130_fd_sc_hd__dfxtp_1
X_2079_ clkload8/A _2079_/D _2044_/A VGND VGND VDPWR VDPWR _2079_/Q sky130_fd_sc_hd__dfrtp_1
Xu_sub.u_core.u_regfile.g_word\[4\].g_byte\[0\].u_lat max_cap120/X max_cap118/X wire116/A
+ max_cap114/X wire112/A max_cap111/X max_cap108/X max_cap106/X u_sub.u_core.u_regfile.g_word\[4\].g_byte\[0\].u_lat/GATE
+ VGND VDPWR u_sub.u_core.u_regfile.g_word\[4\].g_byte\[0\].u_lat/Q0 u_sub.u_core.u_regfile.g_word\[4\].g_byte\[0\].u_lat/Q1
+ u_sub.u_core.u_regfile.g_word\[4\].g_byte\[0\].u_lat/Q2 u_sub.u_core.u_regfile.g_word\[4\].g_byte\[0\].u_lat/Q3
+ u_sub.u_core.u_regfile.g_word\[4\].g_byte\[0\].u_lat/Q4 u_sub.u_core.u_regfile.g_word\[4\].g_byte\[0\].u_lat/Q5
+ u_sub.u_core.u_regfile.g_word\[4\].g_byte\[0\].u_lat/Q6 u_sub.u_core.u_regfile.g_word\[4\].g_byte\[0\].u_lat/Q7
+ dlxtp8_x1
XFILLER_55_97 VGND VGND VDPWR VDPWR sky130_fd_sc_hd__decap_3
XFILLER_71_41 VGND VGND VDPWR VDPWR sky130_fd_sc_hd__decap_3
X_1450_ _1841_/S _2156_/Q VGND VGND VDPWR VDPWR _1450_/Y sky130_fd_sc_hd__nand2_1
X_1381_ _1357_/X _1434_/B _2128_/Q VGND VGND VDPWR VDPWR _1381_/Y sky130_fd_sc_hd__a21boi_1
XFILLER_35_155 VGND VGND VDPWR VDPWR sky130_fd_sc_hd__decap_3
XFILLER_50_125 VGND VGND VDPWR VDPWR sky130_fd_sc_hd__fill_1
XTAP_TAPCELL_ROW_45_183 VGND VDPWR sky130_fd_sc_hd__tapvpwrvgnd_1
X_2002_ _2021_/A1 _2012_/B _2001_/Y VGND VGND VDPWR VDPWR _2134_/D sky130_fd_sc_hd__a21oi_1
XFILLER_50_169 VGND VGND VDPWR VDPWR sky130_fd_sc_hd__decap_3
XFILLER_58_214 VGND VGND VDPWR VDPWR sky130_fd_sc_hd__decap_3
X_1717_ _2067_/Q _1717_/B VGND VGND VDPWR VDPWR _1719_/A sky130_fd_sc_hd__nor2_1
X_1648_ _1647_/B _1342_/Y _1647_/Y VGND VGND VDPWR VDPWR _2194_/D sky130_fd_sc_hd__o21ai_1
X_1579_ _2077_/Q _1580_/B VGND VGND VDPWR VDPWR _1579_/Y sky130_fd_sc_hd__nor2_1
XTAP_TAPCELL_ROW_68_297 VGND VDPWR sky130_fd_sc_hd__tapvpwrvgnd_1
XFILLER_26_188 VGND VGND VDPWR VDPWR sky130_fd_sc_hd__fill_2
XFILLER_41_103 VGND VGND VDPWR VDPWR sky130_fd_sc_hd__decap_3
XFILLER_41_44 VGND VGND VDPWR VDPWR sky130_fd_sc_hd__decap_3
XFILLER_49_225 VGND VGND VDPWR VDPWR sky130_fd_sc_hd__decap_3
XFILLER_49_236 VGND VGND VDPWR VDPWR sky130_fd_sc_hd__fill_2
XTAP_TAPCELL_ROW_59_253 VGND VDPWR sky130_fd_sc_hd__tapvpwrvgnd_1
XFILLER_17_188 VGND VGND VDPWR VDPWR sky130_fd_sc_hd__decap_3
XFILLER_32_103 VGND VGND VDPWR VDPWR sky130_fd_sc_hd__fill_2
XFILLER_32_114 VGND VGND VDPWR VDPWR sky130_fd_sc_hd__decap_3
XFILLER_32_169 VGND VGND VDPWR VDPWR sky130_fd_sc_hd__fill_1
XTAP_TAPCELL_ROW_42_164 VGND VDPWR sky130_fd_sc_hd__tapvpwrvgnd_1
X_1502_ _1499_/Y _1500_/Y _1501_/Y VGND VGND VDPWR VDPWR _2152_/D sky130_fd_sc_hd__o21ai_1
X_1433_ hold23/A _1433_/B VGND VGND VDPWR VDPWR _1930_/A sky130_fd_sc_hd__nand2_1
XFILLER_70_209 VGND VGND VDPWR VDPWR sky130_fd_sc_hd__fill_1
X_1364_ _2150_/Q _2158_/Q VGND VGND VDPWR VDPWR _1723_/C sky130_fd_sc_hd__nand2_1
X_1295_ _1331_/A _1300_/B VGND VGND VDPWR VDPWR _1297_/B sky130_fd_sc_hd__xnor2_1
Xu_sub.u_core.u_regfile.g_word\[4\].g_byte\[0\].u_cg.u_icg clkbuf_leaf_2_clk/X _1545_/Y
+ VGND VGND VDPWR VDPWR u_sub.u_core.u_regfile.g_word\[4\].g_byte\[0\].u_lat/GATE
+ sky130_fd_sc_hd__dlclkp_1
XFILLER_36_66 VGND VGND VDPWR VDPWR sky130_fd_sc_hd__fill_2
XFILLER_61_209 VGND VGND VDPWR VDPWR sky130_fd_sc_hd__fill_1
XFILLER_52_43 VGND VGND VDPWR VDPWR sky130_fd_sc_hd__fill_2
Xu_sub.u_core.u_regfile.g_word\[2\].g_byte\[2\].u_cg.u_icg clkload0/A _1537_/Y VGND
+ VGND VDPWR VDPWR u_sub.u_core.u_regfile.g_word\[2\].g_byte\[2\].u_lat/GATE sky130_fd_sc_hd__dlclkp_1
X_1080_ _1211_/A VGND VGND VDPWR VDPWR _1080_/Y sky130_fd_sc_hd__inv_1
XFILLER_60_220 VGND VGND VDPWR VDPWR sky130_fd_sc_hd__decap_3
X_1982_ _2129_/Q _1981_/Y _2039_/B VGND VGND VDPWR VDPWR _1982_/Y sky130_fd_sc_hd__o21ai_1
XFILLER_13_191 VGND VGND VDPWR VDPWR sky130_fd_sc_hd__decap_3
X_2159__18 VGND VGND VDPWR VDPWR _2159_/D _2159__18/LO sky130_fd_sc_hd__conb_1
X_1416_ _2043_/B _2157_/Q VGND VGND VDPWR VDPWR _1417_/B sky130_fd_sc_hd__nand2_1
X_1347_ _1652_/S _1345_/Y _1346_/Y _1267_/Y VGND VGND VDPWR VDPWR _2178_/D sky130_fd_sc_hd__o22ai_1
XTAP_TAPCELL_ROW_53_226 VGND VDPWR sky130_fd_sc_hd__tapvpwrvgnd_1
Xwire87 wire87/A VGND VGND VDPWR VDPWR wire87/X sky130_fd_sc_hd__buf_2
Xwire76 wire77/X VGND VGND VDPWR VDPWR wire76/X sky130_fd_sc_hd__clkbuf_2
Xwire10 wire10/A VGND VGND VDPWR VDPWR wire9/A sky130_fd_sc_hd__buf_2
X_1278_ _1278_/A _1278_/B VGND VGND VDPWR VDPWR _1278_/Y sky130_fd_sc_hd__nand2_1
XFILLER_19_206 VGND VGND VDPWR VDPWR sky130_fd_sc_hd__fill_1
XFILLER_19_228 VGND VGND VDPWR VDPWR sky130_fd_sc_hd__fill_1
XFILLER_69_106 VGND VGND VDPWR VDPWR sky130_fd_sc_hd__decap_3
X_1201_ _1202_/B _1202_/C _1212_/A VGND VGND VDPWR VDPWR _1201_/Y sky130_fd_sc_hd__o21ai_1
XPHY_EDGE_ROW_47_Right_66 VGND VDPWR sky130_fd_sc_hd__tapvpwrvgnd_1
X_2181_ _2193_/CLK hold42/X VGND VGND VDPWR VDPWR _2181_/Q sky130_fd_sc_hd__dfxtp_1
X_1132_ _1132_/A _1498_/B _1137_/A _1086_/X VGND VGND VDPWR VDPWR _1404_/A sky130_fd_sc_hd__nor4b_1
X_1063_ _2043_/B _2152_/Q VGND VGND VDPWR VDPWR _1756_/B sky130_fd_sc_hd__nand2_1
XPHY_EDGE_ROW_56_Right_75 VGND VDPWR sky130_fd_sc_hd__tapvpwrvgnd_1
XTAP_TAPCELL_ROW_50_207 VGND VDPWR sky130_fd_sc_hd__tapvpwrvgnd_1
Xu_sub.u_core.u_regfile.g_nibsel\[1\].g_nib\[3\].u_m2 u_sub.u_core.u_regfile.g_nibsel\[1\].g_nib\[3\].u_lo/X
+ u_sub.u_core.u_regfile.g_nibsel\[1\].g_nib\[3\].u_hi/X _1583_/Y VGND VGND VDPWR
+ VDPWR u_sub.u_core.u_regfile.g_port\[3\].u_b/A0 sky130_fd_sc_hd__mux2_1
X_1965_ _1934_/A _1964_/Y _1958_/Y VGND VGND VDPWR VDPWR _2122_/D sky130_fd_sc_hd__o21ai_1
Xu_sub.u_timer.u_cg_wd.u_icg delaybuf_3_clk/X _1447_/Y VGND VGND VDPWR VDPWR u_sub.u_timer.u_cg_wd.u_icg/GCLK
+ sky130_fd_sc_hd__dlclkp_1
X_1896_ wire70/X _1894_/X _2044_/A VGND VGND VDPWR VDPWR _1897_/B sky130_fd_sc_hd__o21ai_1
XPHY_EDGE_ROW_65_Right_84 VGND VDPWR sky130_fd_sc_hd__tapvpwrvgnd_1
XFILLER_16_209 VGND VGND VDPWR VDPWR sky130_fd_sc_hd__fill_1
XPHY_EDGE_ROW_74_Right_93 VGND VDPWR sky130_fd_sc_hd__tapvpwrvgnd_1
XFILLER_33_78 VGND VGND VDPWR VDPWR sky130_fd_sc_hd__decap_3
XTAP_TAPCELL_ROW_72_321 VGND VDPWR sky130_fd_sc_hd__tapvpwrvgnd_1
X_1750_ _2078_/Q _1750_/B VGND VGND VDPWR VDPWR _1750_/Y sky130_fd_sc_hd__nand2_1
XPHY_EDGE_ROW_30_2_2_Right_49 VGND VDPWR sky130_fd_sc_hd__tapvpwrvgnd_1
Xmax_cap127 _2077_/Q VGND VGND VDPWR VDPWR _1747_/A sky130_fd_sc_hd__buf_6
Xmax_cap138 _1103_/A VGND VGND VDPWR VDPWR _1104_/A sky130_fd_sc_hd__clkbuf_2
X_1681_ _2213_/D _1687_/B VGND VGND VDPWR VDPWR _1682_/B sky130_fd_sc_hd__nor2_1
XFILLER_38_334 VGND VGND VDPWR VDPWR sky130_fd_sc_hd__fill_2
X_2233_ hold23/A VGND VGND VDPWR VDPWR uio_out[4] sky130_fd_sc_hd__buf_2
X_2164_ _2178_/CLK hold54/X _2044_/A VGND VGND VDPWR VDPWR _2164_/Q sky130_fd_sc_hd__dfrtp_1
XFILLER_53_326 VGND VGND VDPWR VDPWR sky130_fd_sc_hd__fill_2
X_1046_ _1104_/A _1118_/A _1046_/C _1132_/A VGND VGND VDPWR VDPWR _1060_/A sky130_fd_sc_hd__nand4_1
X_2095_ _2095_/CLK _2095_/D VGND VGND VDPWR VDPWR _2095_/Q sky130_fd_sc_hd__dfxtp_1
X_1115_ _1348_/C _1115_/B VGND VGND VDPWR VDPWR _1115_/Y sky130_fd_sc_hd__nand2_1
X_1948_ uio_out[2] _2118_/D VGND VGND VDPWR VDPWR _1948_/Y sky130_fd_sc_hd__nand2_1
X_1879_ _1879_/A _1881_/D VGND VGND VDPWR VDPWR _1890_/B sky130_fd_sc_hd__nand2_1
XFILLER_44_304 VGND VGND VDPWR VDPWR sky130_fd_sc_hd__fill_2
XFILLER_44_326 VGND VGND VDPWR VDPWR sky130_fd_sc_hd__fill_2
XFILLER_56_186 VGND VGND VDPWR VDPWR sky130_fd_sc_hd__decap_3
XFILLER_71_101 VGND VGND VDPWR VDPWR sky130_fd_sc_hd__fill_1
XFILLER_44_66 VGND VGND VDPWR VDPWR sky130_fd_sc_hd__fill_2
XFILLER_71_156 VGND VGND VDPWR VDPWR sky130_fd_sc_hd__decap_3
XFILLER_69_41 VGND VGND VDPWR VDPWR sky130_fd_sc_hd__decap_3
XFILLER_47_131 VGND VGND VDPWR VDPWR sky130_fd_sc_hd__fill_2
XFILLER_47_153 VGND VGND VDPWR VDPWR sky130_fd_sc_hd__decap_3
XFILLER_47_186 VGND VGND VDPWR VDPWR sky130_fd_sc_hd__fill_1
XFILLER_47_197 VGND VGND VDPWR VDPWR sky130_fd_sc_hd__decap_3
XFILLER_62_123 VGND VGND VDPWR VDPWR sky130_fd_sc_hd__decap_3
XFILLER_62_156 VGND VGND VDPWR VDPWR sky130_fd_sc_hd__decap_3
X_1802_ _2134_/Q _1841_/S _1842_/A _1801_/Y VGND VGND VDPWR VDPWR _1802_/Y sky130_fd_sc_hd__o211ai_1
X_1733_ _1421_/A _1478_/B _1732_/Y VGND VGND VDPWR VDPWR _2073_/D sky130_fd_sc_hd__o21ai_1
Xdelaybuf_23_clk delaybuf_23_clk/A VGND VGND VDPWR VDPWR delaybuf_23_clk/X sky130_fd_sc_hd__clkbuf_2
X_1664_ _2068_/Q _1665_/D VGND VGND VDPWR VDPWR _1669_/B sky130_fd_sc_hd__nor2_1
X_1595_ _1827_/B _1595_/B VGND VGND VDPWR VDPWR _1595_/Y sky130_fd_sc_hd__xnor2_1
XFILLER_38_186 VGND VGND VDPWR VDPWR sky130_fd_sc_hd__fill_2
X_2216_ _2220_/D _2219_/GATE VGND VGND VDPWR VDPWR _2216_/Q sky130_fd_sc_hd__dlxtp_1
X_2147_ _2151_/CLK _2147_/D VGND VGND VDPWR VDPWR _2147_/Q sky130_fd_sc_hd__dfxtp_1
XFILLER_41_307 VGND VGND VDPWR VDPWR sky130_fd_sc_hd__fill_1
X_1029_ _1103_/A _1104_/B _1052_/A VGND VGND VDPWR VDPWR _1139_/A sky130_fd_sc_hd__and3_1
X_2078_ clkload7/A _2078_/D _1729_/A VGND VGND VDPWR VDPWR _2078_/Q sky130_fd_sc_hd__dfrtp_1
XFILLER_39_99 VGND VGND VDPWR VDPWR sky130_fd_sc_hd__decap_3
Xdelaybuf_14_clk delaybuf_14_clk/A VGND VGND VDPWR VDPWR delaybuf_14_clk/X sky130_fd_sc_hd__clkbuf_2
XFILLER_44_189 VGND VGND VDPWR VDPWR sky130_fd_sc_hd__decap_3
XFILLER_71_31 VGND VGND VDPWR VDPWR sky130_fd_sc_hd__decap_3
XFILLER_71_53 VGND VGND VDPWR VDPWR sky130_fd_sc_hd__decap_3
XFILLER_65_9 VGND VGND VDPWR VDPWR sky130_fd_sc_hd__decap_3
X_1380_ _1375_/Y _1377_/Y _1379_/Y _1966_/D _2128_/Q VGND VGND VDPWR VDPWR _1434_/B
+ sky130_fd_sc_hd__a32oi_1
X_2001_ _2134_/Q _2021_/A1 _2039_/B VGND VGND VDPWR VDPWR _2001_/Y sky130_fd_sc_hd__o21ai_1
XFILLER_50_159 VGND VGND VDPWR VDPWR sky130_fd_sc_hd__fill_1
XTAP_TAPCELL_ROW_45_184 VGND VDPWR sky130_fd_sc_hd__tapvpwrvgnd_1
X_1716_ _2044_/A _1716_/B VGND VGND VDPWR VDPWR _2066_/D sky130_fd_sc_hd__and2_1
XFILLER_58_226 VGND VGND VDPWR VDPWR sky130_fd_sc_hd__decap_3
X_1647_ _2182_/Q _1647_/B VGND VGND VDPWR VDPWR _1647_/Y sky130_fd_sc_hd__nand2_1
X_1578_ _2077_/Q _1580_/B VGND VGND VDPWR VDPWR _1578_/Y sky130_fd_sc_hd__nand2_1
XTAP_TAPCELL_ROW_68_298 VGND VDPWR sky130_fd_sc_hd__tapvpwrvgnd_1
XFILLER_41_148 VGND VGND VDPWR VDPWR sky130_fd_sc_hd__decap_3
XFILLER_41_89 VGND VGND VDPWR VDPWR sky130_fd_sc_hd__decap_3
XFILLER_49_248 VGND VGND VDPWR VDPWR sky130_fd_sc_hd__fill_2
XTAP_TAPCELL_ROW_59_254 VGND VDPWR sky130_fd_sc_hd__tapvpwrvgnd_1
XFILLER_32_126 VGND VGND VDPWR VDPWR sky130_fd_sc_hd__decap_3
XFILLER_32_137 VGND VGND VDPWR VDPWR sky130_fd_sc_hd__fill_1
XFILLER_32_148 VGND VGND VDPWR VDPWR sky130_fd_sc_hd__fill_1
Xu_sub.u_timer.g_cmp\[0\].u_cg.u_icg clkload3/A _1554_/Y VGND VGND VDPWR VDPWR clkbuf_0_u_sub.u_timer.g_cmp\[0\].g/A
+ sky130_fd_sc_hd__dlclkp_1
XFILLER_40_170 VGND VGND VDPWR VDPWR sky130_fd_sc_hd__fill_1
XFILLER_70_7 VGND VGND VDPWR VDPWR sky130_fd_sc_hd__decap_3
XTAP_TAPCELL_ROW_42_165 VGND VDPWR sky130_fd_sc_hd__tapvpwrvgnd_1
X_1501_ _2152_/Q _1506_/B _1497_/Y _1504_/B VGND VGND VDPWR VDPWR _1501_/Y sky130_fd_sc_hd__a22oi_1
X_1432_ _1432_/A _1433_/B VGND VGND VDPWR VDPWR _1932_/B sky130_fd_sc_hd__and2_1
X_1363_ _1498_/B _1410_/B wire92/X _1363_/D VGND VGND VDPWR VDPWR _1366_/B sky130_fd_sc_hd__nand4_1
XFILLER_48_270 VGND VGND VDPWR VDPWR sky130_fd_sc_hd__fill_2
X_1294_ _1646_/S _1277_/Y _1293_/Y VGND VGND VDPWR VDPWR _1300_/B sky130_fd_sc_hd__o21bai_1
XPHY_EDGE_ROW_24_2_2_Right_43 VGND VDPWR sky130_fd_sc_hd__tapvpwrvgnd_1
X_1981_ wire87/X _1806_/A _1442_/B _2033_/B VGND VGND VDPWR VDPWR _1981_/Y sky130_fd_sc_hd__a31oi_1
XFILLER_47_1 VGND VGND VDPWR VDPWR sky130_fd_sc_hd__fill_1
X_1415_ _1406_/Y _1549_/C _1524_/A VGND VGND VDPWR VDPWR _1415_/Y sky130_fd_sc_hd__o21ai_1
X_1346_ _2117_/Q _2116_/Q VGND VGND VDPWR VDPWR _1346_/Y sky130_fd_sc_hd__xnor2_1
XFILLER_36_273 VGND VGND VDPWR VDPWR sky130_fd_sc_hd__fill_2
Xwire77 wire77/A VGND VGND VDPWR VDPWR wire77/X sky130_fd_sc_hd__clkbuf_2
Xwire11 wire12/X VGND VGND VDPWR VDPWR uio_out[6] sky130_fd_sc_hd__buf_4
X_1277_ _1753_/A _1275_/Y _1276_/Y _1164_/Y VGND VGND VDPWR VDPWR _1277_/Y sky130_fd_sc_hd__a22oi_1
Xu_sub.u_core.u_regfile.g_nibsel\[2\].g_nib\[1\].u_m2 u_sub.u_core.u_regfile.g_nibsel\[2\].g_nib\[1\].u_lo/X
+ u_sub.u_core.u_regfile.g_nibsel\[2\].g_nib\[1\].u_hi/X max_cap1/X VGND VGND VDPWR
+ VDPWR u_sub.u_core.u_regfile.g_port\[1\].u_b/A1 sky130_fd_sc_hd__mux2_1
XFILLER_19_218 VGND VGND VDPWR VDPWR sky130_fd_sc_hd__decap_3
XFILLER_42_276 VGND VGND VDPWR VDPWR sky130_fd_sc_hd__decap_3
XFILLER_42_298 VGND VGND VDPWR VDPWR sky130_fd_sc_hd__fill_1
XFILLER_63_32 VGND VGND VDPWR VDPWR sky130_fd_sc_hd__fill_2
X_2180_ _2193_/CLK hold41/X VGND VGND VDPWR VDPWR hold67/A sky130_fd_sc_hd__dfxtp_1
X_1200_ _1202_/B _1202_/C VGND VGND VDPWR VDPWR _1203_/B sky130_fd_sc_hd__or2_1
X_1131_ _1242_/A _1174_/C VGND VGND VDPWR VDPWR _1280_/B sky130_fd_sc_hd__nand2_1
X_1062_ _2043_/B _2152_/Q VGND VGND VDPWR VDPWR _1753_/A sky130_fd_sc_hd__and2_1
XTAP_TAPCELL_ROW_50_208 VGND VDPWR sky130_fd_sc_hd__tapvpwrvgnd_1
X_1964_ _2215_/D _1936_/Y _1963_/Y VGND VGND VDPWR VDPWR _1964_/Y sky130_fd_sc_hd__a21oi_1
X_1895_ _2112_/Q _1901_/B VGND VGND VDPWR VDPWR _1897_/A sky130_fd_sc_hd__nor2_1
XFILLER_68_151 VGND VGND VDPWR VDPWR sky130_fd_sc_hd__fill_2
X_1329_ _1329_/A _1329_/B _1329_/C VGND VGND VDPWR VDPWR _1329_/Y sky130_fd_sc_hd__nor3_1
XFILLER_33_35 VGND VGND VDPWR VDPWR sky130_fd_sc_hd__fill_1
XFILLER_59_140 VGND VGND VDPWR VDPWR sky130_fd_sc_hd__decap_3
XFILLER_59_151 VGND VGND VDPWR VDPWR sky130_fd_sc_hd__decap_3
XFILLER_30_213 VGND VGND VDPWR VDPWR sky130_fd_sc_hd__fill_2
Xmax_cap106 max_cap107/X VGND VGND VDPWR VDPWR max_cap106/X sky130_fd_sc_hd__buf_6
Xmax_cap117 _2095_/Q VGND VGND VDPWR VDPWR wire116/A sky130_fd_sc_hd__clkbuf_8
Xmax_cap128 _2076_/Q VGND VGND VDPWR VDPWR _1566_/A sky130_fd_sc_hd__buf_6
X_1680_ _2056_/Q wire71/X _2044_/A VGND VGND VDPWR VDPWR _1682_/A sky130_fd_sc_hd__o21ai_1
X_2232_ _2232_/A VGND VGND VDPWR VDPWR uio_oe[5] sky130_fd_sc_hd__buf_2
Xclkbuf_leaf_2_clk clkbuf_leaf_7_clk/A VGND VGND VDPWR VDPWR clkbuf_leaf_2_clk/X sky130_fd_sc_hd__clkbuf_2
X_2163_ _2175_/CLK hold56/X _2039_/B VGND VGND VDPWR VDPWR _2163_/Q sky130_fd_sc_hd__dfrtp_1
X_1114_ _1348_/C _1115_/B VGND VGND VDPWR VDPWR _1114_/X sky130_fd_sc_hd__and2_1
XFILLER_21_235 VGND VGND VDPWR VDPWR sky130_fd_sc_hd__fill_1
XFILLER_65_187 VGND VGND VDPWR VDPWR sky130_fd_sc_hd__decap_3
X_1045_ _1057_/B _1376_/B _1132_/A VGND VGND VDPWR VDPWR _1213_/A sky130_fd_sc_hd__nand3_1
X_2094_ _2096_/CLK _2094_/D VGND VGND VDPWR VDPWR _2094_/Q sky130_fd_sc_hd__dfxtp_1
X_1947_ uio_out[1] _2118_/D _1934_/Y _1946_/Y VGND VGND VDPWR VDPWR _2120_/D sky130_fd_sc_hd__a22o_1
X_1878_ _1878_/A _1729_/A VGND VGND VDPWR VDPWR _2107_/D sky130_fd_sc_hd__nor2b_1
XFILLER_56_143 VGND VGND VDPWR VDPWR sky130_fd_sc_hd__decap_3
XFILLER_71_135 VGND VGND VDPWR VDPWR sky130_fd_sc_hd__fill_1
XFILLER_12_213 VGND VGND VDPWR VDPWR sky130_fd_sc_hd__decap_3
XFILLER_71_168 VGND VGND VDPWR VDPWR sky130_fd_sc_hd__fill_2
XFILLER_60_66 VGND VGND VDPWR VDPWR sky130_fd_sc_hd__fill_2
XFILLER_60_99 VGND VGND VDPWR VDPWR sky130_fd_sc_hd__fill_1
XFILLER_69_31 VGND VGND VDPWR VDPWR sky130_fd_sc_hd__decap_3
XFILLER_69_53 VGND VGND VDPWR VDPWR sky130_fd_sc_hd__decap_3
XFILLER_47_121 VGND VGND VDPWR VDPWR sky130_fd_sc_hd__fill_2
XFILLER_62_135 VGND VGND VDPWR VDPWR sky130_fd_sc_hd__fill_1
XFILLER_62_168 VGND VGND VDPWR VDPWR sky130_fd_sc_hd__fill_2
Xu_sub.u_core.u_regfile.g_word\[3\].g_byte\[3\].u_lat max_cap120/X max_cap118/X wire116/X
+ max_cap114/X wire112/X max_cap110/X max_cap108/X max_cap106/X u_sub.u_core.u_regfile.g_word\[3\].g_byte\[3\].u_lat/GATE
+ VGND VDPWR u_sub.u_core.u_regfile.g_word\[3\].g_byte\[3\].u_lat/Q0 u_sub.u_core.u_regfile.g_word\[3\].g_byte\[3\].u_lat/Q1
+ u_sub.u_core.u_regfile.g_word\[3\].g_byte\[3\].u_lat/Q2 u_sub.u_core.u_regfile.g_word\[3\].g_byte\[3\].u_lat/Q3
+ u_sub.u_core.u_regfile.g_word\[3\].g_byte\[3\].u_lat/Q4 u_sub.u_core.u_regfile.g_word\[3\].g_byte\[3\].u_lat/Q5
+ u_sub.u_core.u_regfile.g_word\[3\].g_byte\[3\].u_lat/Q6 u_sub.u_core.u_regfile.g_word\[3\].g_byte\[3\].u_lat/Q7
+ dlxtp8_x1
X_1801_ _2130_/Q _1841_/S VGND VGND VDPWR VDPWR _1801_/Y sky130_fd_sc_hd__nand2b_1
X_1732_ _1421_/B _1478_/B _2073_/Q VGND VGND VDPWR VDPWR _1732_/Y sky130_fd_sc_hd__o21ai_1
X_1663_ _2071_/Q _2070_/Q VGND VGND VDPWR VDPWR _1665_/D sky130_fd_sc_hd__or2_1
X_1594_ _1827_/B _1595_/B VGND VGND VDPWR VDPWR _1594_/X sky130_fd_sc_hd__xor2_1
XFILLER_38_143 VGND VGND VDPWR VDPWR sky130_fd_sc_hd__decap_3
XFILLER_38_198 VGND VGND VDPWR VDPWR sky130_fd_sc_hd__decap_3
X_2215_ _2215_/CLK _2215_/D VGND VGND VDPWR VDPWR _2223_/D sky130_fd_sc_hd__dfxtp_1
X_2146_ _2160_/CLK _2146_/D VGND VGND VDPWR VDPWR hold64/A sky130_fd_sc_hd__dfxtp_1
X_2077_ clkload7/A _2077_/D _1729_/A VGND VGND VDPWR VDPWR _2077_/Q sky130_fd_sc_hd__dfrtp_1
XPHY_EDGE_ROW_46_Left_105 VGND VDPWR sky130_fd_sc_hd__tapvpwrvgnd_1
X_1028_ _1128_/C _1220_/A _1128_/A _1128_/B VGND VGND VDPWR VDPWR _1485_/A sky130_fd_sc_hd__nand4bb_1
XPHY_EDGE_ROW_55_Left_114 VGND VDPWR sky130_fd_sc_hd__tapvpwrvgnd_1
XFILLER_44_135 VGND VGND VDPWR VDPWR sky130_fd_sc_hd__fill_1
XFILLER_55_33 VGND VGND VDPWR VDPWR sky130_fd_sc_hd__fill_1
XFILLER_55_88 VGND VGND VDPWR VDPWR sky130_fd_sc_hd__decap_3
XFILLER_71_10 VGND VGND VDPWR VDPWR sky130_fd_sc_hd__decap_3
XPHY_EDGE_ROW_64_Left_123 VGND VDPWR sky130_fd_sc_hd__tapvpwrvgnd_1
XFILLER_71_65 VGND VGND VDPWR VDPWR sky130_fd_sc_hd__decap_3
XFILLER_71_98 VGND VGND VDPWR VDPWR sky130_fd_sc_hd__decap_3
Xdelaybuf_7_clk delaybuf_7_clk/A VGND VGND VDPWR VDPWR delaybuf_8_clk/A sky130_fd_sc_hd__clkbuf_2
XPHY_EDGE_ROW_73_Left_132 VGND VDPWR sky130_fd_sc_hd__tapvpwrvgnd_1
X_2000_ _2134_/Q _2004_/C VGND VGND VDPWR VDPWR _2012_/B sky130_fd_sc_hd__xnor2_1
XFILLER_50_105 VGND VGND VDPWR VDPWR sky130_fd_sc_hd__decap_3
XTAP_TAPCELL_ROW_45_185 VGND VDPWR sky130_fd_sc_hd__tapvpwrvgnd_1
X_1715_ _2066_/Q _1714_/C _1714_/Y VGND VGND VDPWR VDPWR _1716_/B sky130_fd_sc_hd__o21ai_1
X_1646_ _2181_/Q _1833_/A _1646_/S VGND VGND VDPWR VDPWR _2193_/D sky130_fd_sc_hd__mux2_1
XFILLER_58_205 VGND VGND VDPWR VDPWR sky130_fd_sc_hd__decap_3
Xwire7 wire7/A VGND VGND VDPWR VDPWR wire7/X sky130_fd_sc_hd__buf_4
X_1577_ _2086_/Q _1179_/B _1590_/B VGND VGND VDPWR VDPWR _1580_/B sky130_fd_sc_hd__mux2_1
XTAP_TAPCELL_ROW_68_299 VGND VDPWR sky130_fd_sc_hd__tapvpwrvgnd_1
X_2129_ _2160_/CLK _2129_/D VGND VGND VDPWR VDPWR _2129_/Q sky130_fd_sc_hd__dfxtp_1
XFILLER_41_35 VGND VGND VDPWR VDPWR sky130_fd_sc_hd__decap_3
XPHY_EDGE_ROW_11_2_2_Left_0 VGND VDPWR sky130_fd_sc_hd__tapvpwrvgnd_1
XFILLER_57_271 VGND VGND VDPWR VDPWR sky130_fd_sc_hd__fill_2
XTAP_TAPCELL_ROW_59_255 VGND VDPWR sky130_fd_sc_hd__tapvpwrvgnd_1
Xclkbuf_1_0__f_u_sub.u_timer.u_cg_wd.gclk_o clkbuf_0_u_sub.u_timer.u_cg_wd.gclk_o/X
+ VGND VGND VDPWR VDPWR _2215_/CLK sky130_fd_sc_hd__clkbuf_2
XTAP_TAPCELL_ROW_42_166 VGND VDPWR sky130_fd_sc_hd__tapvpwrvgnd_1
Xu_sub.u_core.u_regfile.g_nibsel\[2\].g_nib\[3\].u_hi u_sub.u_core.u_regfile.g_word\[2\].g_byte\[2\].u_lat/Q3
+ u_sub.u_core.u_regfile.g_word\[2\].g_byte\[2\].u_lat/Q7 u_sub.u_core.u_regfile.g_word\[2\].g_byte\[3\].u_lat/Q3
+ u_sub.u_core.u_regfile.g_word\[2\].g_byte\[3\].u_lat/Q7 max_cap4/X max_cap2/X VGND
+ VGND VDPWR VDPWR u_sub.u_core.u_regfile.g_nibsel\[2\].g_nib\[3\].u_hi/X tg_mux4_x1
X_1500_ _1590_/B _1562_/B _1488_/X VGND VGND VDPWR VDPWR _1500_/Y sky130_fd_sc_hd__o21ai_1
X_1431_ _1431_/A _1431_/B VGND VGND VDPWR VDPWR _1431_/Y sky130_fd_sc_hd__nand2_1
X_1362_ _1756_/B _1461_/A VGND VGND VDPWR VDPWR _1363_/D sky130_fd_sc_hd__nor2_1
X_1293_ _1314_/B _1164_/Y _1285_/Y _1292_/Y _1110_/C VGND VGND VDPWR VDPWR _1293_/Y
+ sky130_fd_sc_hd__a2111oi_1
XFILLER_48_282 VGND VGND VDPWR VDPWR sky130_fd_sc_hd__fill_2
X_1629_ _1780_/A _1622_/X _1628_/Y VGND VGND VDPWR VDPWR _1629_/Y sky130_fd_sc_hd__o21ai_1
XFILLER_46_208 VGND VGND VDPWR VDPWR sky130_fd_sc_hd__decap_3
XTAP_TAPCELL_ROW_64_280 VGND VDPWR sky130_fd_sc_hd__tapvpwrvgnd_1
XFILLER_45_296 VGND VGND VDPWR VDPWR sky130_fd_sc_hd__decap_3
XFILLER_60_200 VGND VGND VDPWR VDPWR sky130_fd_sc_hd__decap_3
XFILLER_60_211 VGND VGND VDPWR VDPWR sky130_fd_sc_hd__decap_3
X_1980_ _2141_/Q _2142_/Q _2027_/A _2143_/Q VGND VGND VDPWR VDPWR _2033_/B sky130_fd_sc_hd__a31oi_1
XTAP_TAPCELL_ROW_78_350 VGND VDPWR sky130_fd_sc_hd__tapvpwrvgnd_1
X_1414_ _1406_/Y _1510_/A _1524_/A VGND VGND VDPWR VDPWR _1414_/Y sky130_fd_sc_hd__o21ai_1
X_1345_ _2182_/Q _1221_/B _1343_/Y _1344_/Y VGND VGND VDPWR VDPWR _1345_/Y sky130_fd_sc_hd__a22oi_1
X_1276_ _1753_/A _1276_/B VGND VGND VDPWR VDPWR _1276_/Y sky130_fd_sc_hd__nor2_1
Xwire89 wire89/A VGND VGND VDPWR VDPWR wire89/X sky130_fd_sc_hd__clkbuf_2
Xwire12 wire12/A VGND VGND VDPWR VDPWR wire12/X sky130_fd_sc_hd__buf_2
X_1130_ _1220_/A _1130_/B _1130_/C VGND VGND VDPWR VDPWR _1174_/C sky130_fd_sc_hd__nand3_1
XFILLER_33_233 VGND VGND VDPWR VDPWR sky130_fd_sc_hd__fill_1
XTAP_TAPCELL_ROW_50_209 VGND VDPWR sky130_fd_sc_hd__tapvpwrvgnd_1
X_1061_ _1798_/A _1215_/A _1060_/Y VGND VGND VDPWR VDPWR _1593_/A sky130_fd_sc_hd__a21oi_1
X_1963_ _1963_/A _1963_/B _1963_/C VGND VGND VDPWR VDPWR _1963_/Y sky130_fd_sc_hd__nor3_1
X_1894_ _1894_/A _2038_/A _2037_/A _1894_/D VGND VGND VDPWR VDPWR _1894_/X sky130_fd_sc_hd__or4_1
XFILLER_71_339 VGND VGND VDPWR VDPWR sky130_fd_sc_hd__fill_1
X_1328_ _1117_/C _1242_/A _1894_/A VGND VGND VDPWR VDPWR _1329_/C sky130_fd_sc_hd__a21oi_1
X_1259_ _1259_/A _1259_/B VGND VGND VDPWR VDPWR _1259_/Y sky130_fd_sc_hd__nor2_1
XFILLER_33_69 VGND VGND VDPWR VDPWR sky130_fd_sc_hd__decap_3
XFILLER_58_66 VGND VGND VDPWR VDPWR sky130_fd_sc_hd__fill_2
XFILLER_58_88 VGND VGND VDPWR VDPWR sky130_fd_sc_hd__decap_3
XFILLER_15_222 VGND VGND VDPWR VDPWR sky130_fd_sc_hd__decap_3
Xmax_cap107 _2100_/Q VGND VGND VDPWR VDPWR max_cap107/X sky130_fd_sc_hd__clkbuf_8
X_2231_ _2232_/A VGND VGND VDPWR VDPWR uio_oe[4] sky130_fd_sc_hd__buf_2
Xmax_cap118 max_cap119/X VGND VGND VDPWR VDPWR max_cap118/X sky130_fd_sc_hd__clkbuf_8
X_1044_ _1485_/A _1485_/B _1076_/B VGND VGND VDPWR VDPWR _1215_/A sky130_fd_sc_hd__nor3_1
X_2162_ clkload6/A _2162_/D _1729_/A VGND VGND VDPWR VDPWR _2162_/Q sky130_fd_sc_hd__dfrtp_1
X_2093_ _2095_/CLK _2093_/D VGND VGND VDPWR VDPWR _2093_/Q sky130_fd_sc_hd__dfxtp_1
X_1113_ _1166_/A _1278_/A _1348_/A _1179_/B VGND VGND VDPWR VDPWR _1120_/D sky130_fd_sc_hd__nor4_1
XFILLER_21_225 VGND VGND VDPWR VDPWR sky130_fd_sc_hd__fill_2
X_1946_ _1946_/A _1946_/B VGND VGND VDPWR VDPWR _1946_/Y sky130_fd_sc_hd__nand2_1
X_1877_ _2107_/Q _1724_/B _1869_/A VGND VGND VDPWR VDPWR _1878_/A sky130_fd_sc_hd__a21oi_1
XTAP_TAPCELL_ROW_41_1_1_156 VGND VDPWR sky130_fd_sc_hd__tapvpwrvgnd_1
XFILLER_44_339 VGND VGND VDPWR VDPWR sky130_fd_sc_hd__fill_1
XFILLER_56_166 VGND VGND VDPWR VDPWR sky130_fd_sc_hd__decap_3
XFILLER_8_229 VGND VGND VDPWR VDPWR sky130_fd_sc_hd__fill_1
XFILLER_69_10 VGND VGND VDPWR VDPWR sky130_fd_sc_hd__decap_3
XFILLER_47_177 VGND VGND VDPWR VDPWR sky130_fd_sc_hd__decap_3
XFILLER_62_114 VGND VGND VDPWR VDPWR sky130_fd_sc_hd__decap_3
Xclkbuf_1_0__f_u_sub.u_core.addr_gclk clkbuf_0_u_sub.u_core.addr_gclk/X VGND VGND
+ VDPWR VDPWR _2193_/CLK sky130_fd_sc_hd__clkbuf_2
X_1800_ wire96/X _1798_/X _1799_/Y VGND VGND VDPWR VDPWR _2092_/D sky130_fd_sc_hd__a21oi_1
X_1731_ _2071_/Q _1729_/B _1730_/Y VGND VGND VDPWR VDPWR _2072_/D sky130_fd_sc_hd__a21oi_1
X_1662_ _2054_/Q _2053_/Q _1720_/B VGND VGND VDPWR VDPWR _1666_/C sky130_fd_sc_hd__or3_1
X_2214_ _2215_/CLK _2214_/D VGND VGND VDPWR VDPWR _2222_/D sky130_fd_sc_hd__dfxtp_1
X_1593_ _1593_/A _1593_/B _1757_/B _1827_/C VGND VGND VDPWR VDPWR _1595_/B sky130_fd_sc_hd__nand4_1
XFILLER_38_155 VGND VGND VDPWR VDPWR sky130_fd_sc_hd__fill_2
XFILLER_53_114 VGND VGND VDPWR VDPWR sky130_fd_sc_hd__decap_3
XFILLER_53_169 VGND VGND VDPWR VDPWR sky130_fd_sc_hd__fill_1
X_1027_ _1128_/C _1220_/A _1128_/A _1128_/B VGND VGND VDPWR VDPWR _1052_/A sky130_fd_sc_hd__nor4bb_1
X_2145_ _2160_/CLK _2145_/D VGND VGND VDPWR VDPWR _2145_/Q sky130_fd_sc_hd__dfxtp_1
X_2076_ clkload7/A _2076_/D _1729_/A VGND VGND VDPWR VDPWR _2076_/Q sky130_fd_sc_hd__dfrtp_1
XFILLER_61_180 VGND VGND VDPWR VDPWR sky130_fd_sc_hd__decap_3
X_1929_ _2127_/Q _2126_/Q _2125_/Q _2124_/Q VGND VGND VDPWR VDPWR _1931_/B sky130_fd_sc_hd__nand4_1
XFILLER_39_24 VGND VGND VDPWR VDPWR sky130_fd_sc_hd__fill_1
XFILLER_29_188 VGND VGND VDPWR VDPWR sky130_fd_sc_hd__decap_3
XFILLER_39_35 VGND VGND VDPWR VDPWR sky130_fd_sc_hd__fill_2
XFILLER_52_191 VGND VGND VDPWR VDPWR sky130_fd_sc_hd__decap_3
XFILLER_71_22 VGND VGND VDPWR VDPWR sky130_fd_sc_hd__decap_3
XFILLER_71_44 VGND VGND VDPWR VDPWR sky130_fd_sc_hd__decap_3
XFILLER_35_103 VGND VGND VDPWR VDPWR sky130_fd_sc_hd__fill_2
XFILLER_35_169 VGND VGND VDPWR VDPWR sky130_fd_sc_hd__fill_1
XFILLER_50_117 VGND VGND VDPWR VDPWR sky130_fd_sc_hd__fill_2
XTAP_TAPCELL_ROW_45_186 VGND VDPWR sky130_fd_sc_hd__tapvpwrvgnd_1
X_1714_ _2066_/Q _1714_/B _1714_/C VGND VGND VDPWR VDPWR _1714_/Y sky130_fd_sc_hd__nand3_1
X_1645_ _1647_/B _1263_/Y _1644_/Y VGND VGND VDPWR VDPWR _2192_/D sky130_fd_sc_hd__o21ai_1
X_1576_ _1841_/S _1559_/B _1571_/B _1569_/Y VGND VGND VDPWR VDPWR _1581_/A sky130_fd_sc_hd__a31oi_1
XFILLER_58_217 VGND VGND VDPWR VDPWR sky130_fd_sc_hd__decap_3
Xu_sub.u_core.u_regfile.g_nibsel\[3\].g_nib\[1\].u_hi u_sub.u_core.u_regfile.g_word\[3\].g_byte\[2\].u_lat/Q1
+ u_sub.u_core.u_regfile.g_word\[3\].g_byte\[2\].u_lat/Q5 u_sub.u_core.u_regfile.g_word\[3\].g_byte\[3\].u_lat/Q1
+ u_sub.u_core.u_regfile.g_word\[3\].g_byte\[3\].u_lat/Q5 max_cap4/X max_cap2/X VGND
+ VGND VDPWR VDPWR u_sub.u_core.u_regfile.g_nibsel\[3\].g_nib\[1\].u_hi/X tg_mux4_x1
XFILLER_41_106 VGND VGND VDPWR VDPWR sky130_fd_sc_hd__decap_3
X_2128_ clkload8/A _2128_/D VGND VGND VDPWR VDPWR _2128_/Q sky130_fd_sc_hd__dfxtp_1
X_2059_ clkload6/A _2059_/D VGND VGND VDPWR VDPWR _2059_/Q sky130_fd_sc_hd__dfxtp_1
XFILLER_41_47 VGND VGND VDPWR VDPWR sky130_fd_sc_hd__decap_3
Xu_sub.u_core.u_regfile.g_ir\[3\].u_lat _2093_/Q _2094_/Q wire116/X _2096_/Q wire112/X
+ max_cap110/X _2099_/Q max_cap107/X u_sub.u_core.u_regfile.g_ir\[3\].u_lat/GATE VGND
+ VDPWR _1179_/B _1117_/B _1282_/B _1117_/C _1121_/B _1142_/A _1118_/A _1174_/B dlxtp8_x1
XFILLER_49_206 VGND VGND VDPWR VDPWR sky130_fd_sc_hd__decap_3
XFILLER_49_228 VGND VGND VDPWR VDPWR sky130_fd_sc_hd__decap_3
XFILLER_57_283 VGND VGND VDPWR VDPWR sky130_fd_sc_hd__fill_2
XTAP_TAPCELL_ROW_59_256 VGND VDPWR sky130_fd_sc_hd__tapvpwrvgnd_1
XFILLER_32_117 VGND VGND VDPWR VDPWR sky130_fd_sc_hd__decap_3
XTAP_TAPCELL_ROW_42_167 VGND VDPWR sky130_fd_sc_hd__tapvpwrvgnd_1
X_1430_ _1430_/A _1430_/B VGND VGND VDPWR VDPWR _1430_/X sky130_fd_sc_hd__or2_1
X_1361_ _1458_/B _1442_/A _1361_/C VGND VGND VDPWR VDPWR _1461_/A sky130_fd_sc_hd__nor3_1
X_1292_ _1292_/A _1292_/B VGND VGND VDPWR VDPWR _1292_/Y sky130_fd_sc_hd__nor2_1
Xu_sub.u_core.u_regfile.g_ir\[1\].u_cg.u_icg clkload1/A _1551_/Y VGND VGND VDPWR VDPWR
+ u_sub.u_core.u_regfile.g_ir\[1\].u_lat/GATE sky130_fd_sc_hd__dlclkp_1
X_1628_ _2145_/Q _1844_/B _1627_/Y VGND VGND VDPWR VDPWR _1628_/Y sky130_fd_sc_hd__a21oi_1
X_1559_ _1791_/A _1559_/B VGND VGND VDPWR VDPWR _1560_/B sky130_fd_sc_hd__xnor2_1
XFILLER_39_272 VGND VGND VDPWR VDPWR sky130_fd_sc_hd__decap_3
XTAP_TAPCELL_ROW_56_237 VGND VDPWR sky130_fd_sc_hd__tapvpwrvgnd_1
XTAP_TAPCELL_ROW_64_281 VGND VDPWR sky130_fd_sc_hd__tapvpwrvgnd_1
XFILLER_45_264 VGND VGND VDPWR VDPWR sky130_fd_sc_hd__fill_1
XFILLER_60_223 VGND VGND VDPWR VDPWR sky130_fd_sc_hd__decap_3
XFILLER_60_234 VGND VGND VDPWR VDPWR sky130_fd_sc_hd__fill_1
XFILLER_13_194 VGND VGND VDPWR VDPWR sky130_fd_sc_hd__fill_1
X_1413_ _1510_/A VGND VGND VDPWR VDPWR _1549_/C sky130_fd_sc_hd__inv_1
XTAP_TAPCELL_ROW_78_351 VGND VDPWR sky130_fd_sc_hd__tapvpwrvgnd_1
X_1344_ _1471_/B _1342_/Y _1221_/B VGND VGND VDPWR VDPWR _1344_/Y sky130_fd_sc_hd__a21oi_1
X_1275_ _1002_/Y _1590_/B _1276_/B _1567_/B VGND VGND VDPWR VDPWR _1275_/Y sky130_fd_sc_hd__o22ai_1
XTAP_TAPCELL_ROW_61_262 VGND VDPWR sky130_fd_sc_hd__tapvpwrvgnd_1
Xwire79 wire80/X VGND VGND VDPWR VDPWR wire79/X sky130_fd_sc_hd__buf_1
XFILLER_47_35 VGND VGND VDPWR VDPWR sky130_fd_sc_hd__fill_1
XFILLER_63_23 VGND VGND VDPWR VDPWR sky130_fd_sc_hd__decap_3
XTAP_TAPCELL_ROW_75_332 VGND VDPWR sky130_fd_sc_hd__tapvpwrvgnd_1
X_1060_ _1060_/A _1060_/B _1060_/C VGND VGND VDPWR VDPWR _1060_/Y sky130_fd_sc_hd__nand3_1
XFILLER_33_256 VGND VGND VDPWR VDPWR sky130_fd_sc_hd__decap_3
XFILLER_37_90 VGND VGND VDPWR VDPWR sky130_fd_sc_hd__decap_3
X_1962_ _1623_/C _1970_/B _1961_/X _1941_/A VGND VGND VDPWR VDPWR _1963_/C sky130_fd_sc_hd__o22ai_1
XFILLER_52_1 VGND VGND VDPWR VDPWR sky130_fd_sc_hd__fill_2
X_1893_ _1894_/A _2038_/A _2037_/A _1894_/D VGND VGND VDPWR VDPWR _1901_/B sky130_fd_sc_hd__nor4_1
XFILLER_24_212 VGND VGND VDPWR VDPWR sky130_fd_sc_hd__decap_3
X_1327_ _1322_/X _1324_/Y _1326_/Y _2077_/Q VGND VGND VDPWR VDPWR _1329_/B sky130_fd_sc_hd__a31oi_1
X_1258_ _1259_/A _1259_/B VGND VGND VDPWR VDPWR _1260_/B sky130_fd_sc_hd__nand2_1
X_1189_ _1841_/S _1326_/A _1189_/C VGND VGND VDPWR VDPWR _1189_/Y sky130_fd_sc_hd__nand3_1
XPHY_EDGE_ROW_43_Right_62 VGND VDPWR sky130_fd_sc_hd__tapvpwrvgnd_1
XPHY_EDGE_ROW_52_Right_71 VGND VDPWR sky130_fd_sc_hd__tapvpwrvgnd_1
XFILLER_15_212 VGND VGND VDPWR VDPWR sky130_fd_sc_hd__decap_3
XFILLER_15_234 VGND VGND VDPWR VDPWR sky130_fd_sc_hd__fill_2
XPHY_EDGE_ROW_36_2_2_Right_55 VGND VDPWR sky130_fd_sc_hd__tapvpwrvgnd_1
XPHY_EDGE_ROW_61_Right_80 VGND VDPWR sky130_fd_sc_hd__tapvpwrvgnd_1
Xmax_cap108 max_cap109/X VGND VGND VDPWR VDPWR max_cap108/X sky130_fd_sc_hd__clkbuf_8
Xmax_cap119 _2094_/Q VGND VGND VDPWR VDPWR max_cap119/X sky130_fd_sc_hd__buf_6
Xu_sub.u_core.u_regfile.g_word\[1\].g_byte\[1\].u_cg.u_icg clkbuf_leaf_3_clk/X _1528_/Y
+ VGND VGND VDPWR VDPWR u_sub.u_core.u_regfile.g_word\[1\].g_byte\[1\].u_lat/GATE
+ sky130_fd_sc_hd__dlclkp_1
X_2230_ _2230_/A VGND VGND VDPWR VDPWR uio_oe[3] sky130_fd_sc_hd__buf_2
XFILLER_65_178 VGND VGND VDPWR VDPWR sky130_fd_sc_hd__decap_3
X_1043_ _1057_/B _1376_/B VGND VGND VDPWR VDPWR _1076_/B sky130_fd_sc_hd__nand2_1
X_2161_ clkload9/A ui_in[7] hold20/X VGND VGND VDPWR VDPWR _2162_/D sky130_fd_sc_hd__dfrtp_1
X_2092_ clkload9/A _2092_/D VGND VGND VDPWR VDPWR _2092_/Q sky130_fd_sc_hd__dfxtp_1
X_1112_ _1179_/B _1166_/A VGND VGND VDPWR VDPWR _1112_/Y sky130_fd_sc_hd__nor2b_1
X_1945_ _2213_/D _1357_/X _1936_/B VGND VGND VDPWR VDPWR _1946_/B sky130_fd_sc_hd__a21oi_1
X_1876_ _2106_/Q _1869_/A _1875_/Y _1729_/A VGND VGND VDPWR VDPWR _2106_/D sky130_fd_sc_hd__o211a_1
XTAP_TAPCELL_ROW_22_2_2_146 VGND VDPWR sky130_fd_sc_hd__tapvpwrvgnd_1
XTAP_TAPCELL_ROW_41_1_1_157 VGND VDPWR sky130_fd_sc_hd__tapvpwrvgnd_1
XFILLER_56_189 VGND VGND VDPWR VDPWR sky130_fd_sc_hd__decap_3
XFILLER_71_159 VGND VGND VDPWR VDPWR sky130_fd_sc_hd__decap_3
XFILLER_69_22 VGND VGND VDPWR VDPWR sky130_fd_sc_hd__decap_3
XFILLER_69_44 VGND VGND VDPWR VDPWR sky130_fd_sc_hd__decap_3
Xdelaybuf_17_clk clkbuf_0_clk/X VGND VGND VDPWR VDPWR delaybuf_18_clk/A sky130_fd_sc_hd__clkbuf_2
XFILLER_47_156 VGND VGND VDPWR VDPWR sky130_fd_sc_hd__decap_3
XFILLER_47_167 VGND VGND VDPWR VDPWR sky130_fd_sc_hd__decap_3
XFILLER_62_126 VGND VGND VDPWR VDPWR sky130_fd_sc_hd__decap_3
XFILLER_62_137 VGND VGND VDPWR VDPWR sky130_fd_sc_hd__decap_3
XFILLER_62_148 VGND VGND VDPWR VDPWR sky130_fd_sc_hd__fill_2
XFILLER_62_159 VGND VGND VDPWR VDPWR sky130_fd_sc_hd__decap_3
X_1730_ _2072_/Q _1729_/B _1729_/A VGND VGND VDPWR VDPWR _1730_/Y sky130_fd_sc_hd__o21ai_1
X_1661_ _2150_/Q _2158_/Q _1723_/B wire7/X VGND VGND VDPWR VDPWR _1720_/B sky130_fd_sc_hd__nand4_1
X_1592_ _2087_/Q _1590_/B _1590_/Y VGND VGND VDPWR VDPWR _1834_/A sky130_fd_sc_hd__o21ai_1
XFILLER_38_134 VGND VGND VDPWR VDPWR sky130_fd_sc_hd__fill_2
X_2213_ _2213_/CLK _2213_/D VGND VGND VDPWR VDPWR _2221_/D sky130_fd_sc_hd__dfxtp_1
X_2144_ _2160_/CLK _2144_/D VGND VGND VDPWR VDPWR _2144_/Q sky130_fd_sc_hd__dfxtp_1
XFILLER_38_167 VGND VGND VDPWR VDPWR sky130_fd_sc_hd__decap_3
XFILLER_53_148 VGND VGND VDPWR VDPWR sky130_fd_sc_hd__fill_2
X_1026_ _2117_/Q _2116_/Q _1624_/A _1421_/A VGND VGND VDPWR VDPWR _1026_/Y sky130_fd_sc_hd__a31oi_1
X_2075_ clkload7/A _2075_/D _1729_/A VGND VGND VDPWR VDPWR _2075_/Q sky130_fd_sc_hd__dfrtp_1
X_1928_ _1963_/A _1928_/B _1928_/C VGND VGND VDPWR VDPWR _1928_/Y sky130_fd_sc_hd__nor3_1
X_1859_ _1852_/A _1858_/Y _1524_/A VGND VGND VDPWR VDPWR _1859_/Y sky130_fd_sc_hd__o21ai_1
XFILLER_55_35 VGND VGND VDPWR VDPWR sky130_fd_sc_hd__decap_3
XFILLER_52_181 VGND VGND VDPWR VDPWR sky130_fd_sc_hd__decap_3
XFILLER_71_56 VGND VGND VDPWR VDPWR sky130_fd_sc_hd__decap_3
X_1713_ _1708_/B _1710_/Y _1712_/Y VGND VGND VDPWR VDPWR _2065_/D sky130_fd_sc_hd__a21oi_1
Xwire9 wire9/A VGND VGND VDPWR VDPWR uio_out[7] sky130_fd_sc_hd__buf_4
X_1644_ _1644_/A _1647_/B VGND VGND VDPWR VDPWR _1644_/Y sky130_fd_sc_hd__nand2_1
X_1575_ _1747_/A _1771_/A VGND VGND VDPWR VDPWR _1575_/Y sky130_fd_sc_hd__nand2_1
XFILLER_58_229 VGND VGND VDPWR VDPWR sky130_fd_sc_hd__fill_1
X_2127_ clkload9/A _2127_/D VGND VGND VDPWR VDPWR _2127_/Q sky130_fd_sc_hd__dfxtp_1
X_1009_ _1348_/A VGND VGND VDPWR VDPWR _1009_/Y sky130_fd_sc_hd__inv_1
X_2058_ clkload7/A _2058_/D VGND VGND VDPWR VDPWR _2058_/Q sky130_fd_sc_hd__dfxtp_1
XFILLER_41_59 VGND VGND VDPWR VDPWR sky130_fd_sc_hd__decap_3
XFILLER_32_129 VGND VGND VDPWR VDPWR sky130_fd_sc_hd__decap_3
XFILLER_66_89 VGND VGND VDPWR VDPWR sky130_fd_sc_hd__fill_2
XTAP_TAPCELL_ROW_42_168 VGND VDPWR sky130_fd_sc_hd__tapvpwrvgnd_1
Xu_sub.u_core.u_regfile.g_nibsel\[2\].g_nib\[3\].u_lo u_sub.u_core.u_regfile.g_word\[2\].g_byte\[0\].u_lat/Q3
+ u_sub.u_core.u_regfile.g_word\[2\].g_byte\[0\].u_lat/Q7 u_sub.u_core.u_regfile.g_word\[2\].g_byte\[1\].u_lat/Q3
+ u_sub.u_core.u_regfile.g_word\[2\].g_byte\[1\].u_lat/Q7 max_cap4/X max_cap2/X VGND
+ VGND VDPWR VDPWR u_sub.u_core.u_regfile.g_nibsel\[2\].g_nib\[3\].u_lo/X tg_mux4_x1
X_1360_ _1747_/A _1360_/B VGND VGND VDPWR VDPWR _1361_/C sky130_fd_sc_hd__nor2_1
XFILLER_48_251 VGND VGND VDPWR VDPWR sky130_fd_sc_hd__decap_3
XFILLER_48_273 VGND VGND VDPWR VDPWR sky130_fd_sc_hd__fill_2
X_1291_ _1204_/B _1289_/Y _1290_/Y VGND VGND VDPWR VDPWR _1292_/B sky130_fd_sc_hd__o21ai_1
XPHY_EDGE_ROW_40_2_2_Left_29 VGND VDPWR sky130_fd_sc_hd__tapvpwrvgnd_1
X_1627_ _1894_/D _1627_/B VGND VGND VDPWR VDPWR _1627_/Y sky130_fd_sc_hd__nor2_1
X_1558_ _1841_/S _1559_/B VGND VGND VDPWR VDPWR _1572_/A sky130_fd_sc_hd__nand2_1
X_1489_ _2043_/B _1477_/B _2157_/Q VGND VGND VDPWR VDPWR _1489_/Y sky130_fd_sc_hd__o21ai_1
XTAP_TAPCELL_ROW_56_238 VGND VDPWR sky130_fd_sc_hd__tapvpwrvgnd_1
XFILLER_52_69 VGND VGND VDPWR VDPWR sky130_fd_sc_hd__fill_2
XFILLER_45_287 VGND VGND VDPWR VDPWR sky130_fd_sc_hd__decap_3
XFILLER_9_188 VGND VGND VDPWR VDPWR sky130_fd_sc_hd__decap_3
X_1412_ _1841_/S _1412_/B VGND VGND VDPWR VDPWR _1510_/A sky130_fd_sc_hd__xnor2_1
X_1343_ _2198_/Q _1343_/B VGND VGND VDPWR VDPWR _1343_/Y sky130_fd_sc_hd__nand2b_1
X_1274_ _1215_/C _1272_/Y _1273_/Y VGND VGND VDPWR VDPWR _1300_/A sky130_fd_sc_hd__a21oi_1
XTAP_TAPCELL_ROW_61_263 VGND VDPWR sky130_fd_sc_hd__tapvpwrvgnd_1
XTAP_TAPCELL_ROW_30_2_2_150 VGND VDPWR sky130_fd_sc_hd__tapvpwrvgnd_1
XFILLER_42_279 VGND VGND VDPWR VDPWR sky130_fd_sc_hd__fill_1
XFILLER_63_35 VGND VGND VDPWR VDPWR sky130_fd_sc_hd__decap_3
XTAP_TAPCELL_ROW_75_333 VGND VDPWR sky130_fd_sc_hd__tapvpwrvgnd_1
XFILLER_53_90 VGND VGND VDPWR VDPWR sky130_fd_sc_hd__decap_3
X_1961_ hold50/A hold49/A hold66/A hold63/A _2124_/Q _1959_/A VGND VGND VDPWR VDPWR
+ _1961_/X sky130_fd_sc_hd__mux4_2
X_1892_ _1892_/A _1892_/B VGND VGND VDPWR VDPWR _2111_/D sky130_fd_sc_hd__nor2_1
XFILLER_45_1 VGND VGND VDPWR VDPWR sky130_fd_sc_hd__fill_2
XFILLER_5_191 VGND VGND VDPWR VDPWR sky130_fd_sc_hd__decap_3
XFILLER_68_110 VGND VGND VDPWR VDPWR sky130_fd_sc_hd__fill_2
Xclkbuf_leaf_5_clk delaybuf_16_clk/A VGND VGND VDPWR VDPWR clkload3/A sky130_fd_sc_hd__clkbuf_2
X_1326_ _1326_/A _1326_/B VGND VGND VDPWR VDPWR _1326_/Y sky130_fd_sc_hd__nand2_1
XPHY_EDGE_ROW_17_2_2_Right_36 VGND VDPWR sky130_fd_sc_hd__tapvpwrvgnd_1
X_1257_ _1257_/A _1257_/B VGND VGND VDPWR VDPWR _1257_/X sky130_fd_sc_hd__xor2_1
X_1188_ _1188_/A _1280_/B VGND VGND VDPWR VDPWR _1189_/C sky130_fd_sc_hd__nand2_1
Xu_sub.u_core.u_regfile.g_word\[2\].g_byte\[2\].u_lat max_cap120/X max_cap118/X wire116/X
+ max_cap114/X wire112/X max_cap110/X max_cap108/X max_cap106/X u_sub.u_core.u_regfile.g_word\[2\].g_byte\[2\].u_lat/GATE
+ VGND VDPWR u_sub.u_core.u_regfile.g_word\[2\].g_byte\[2\].u_lat/Q0 u_sub.u_core.u_regfile.g_word\[2\].g_byte\[2\].u_lat/Q1
+ u_sub.u_core.u_regfile.g_word\[2\].g_byte\[2\].u_lat/Q2 u_sub.u_core.u_regfile.g_word\[2\].g_byte\[2\].u_lat/Q3
+ u_sub.u_core.u_regfile.g_word\[2\].g_byte\[2\].u_lat/Q4 u_sub.u_core.u_regfile.g_word\[2\].g_byte\[2\].u_lat/Q5
+ u_sub.u_core.u_regfile.g_word\[2\].g_byte\[2\].u_lat/Q6 u_sub.u_core.u_regfile.g_word\[2\].g_byte\[2\].u_lat/Q7
+ dlxtp8_x1
XFILLER_58_79 VGND VGND VDPWR VDPWR sky130_fd_sc_hd__fill_2
XFILLER_59_143 VGND VGND VDPWR VDPWR sky130_fd_sc_hd__fill_1
XFILLER_59_154 VGND VGND VDPWR VDPWR sky130_fd_sc_hd__fill_2
XFILLER_59_165 VGND VGND VDPWR VDPWR sky130_fd_sc_hd__decap_3
XFILLER_62_319 VGND VGND VDPWR VDPWR sky130_fd_sc_hd__fill_1
XFILLER_70_341 VGND VGND VDPWR VDPWR sky130_fd_sc_hd__decap_3
Xmax_cap109 _2099_/Q VGND VGND VDPWR VDPWR max_cap109/X sky130_fd_sc_hd__buf_6
XFILLER_2_194 VGND VGND VDPWR VDPWR sky130_fd_sc_hd__decap_3
X_2160_ _2160_/CLK hold51/X rst_n VGND VGND VDPWR VDPWR hold21/A sky130_fd_sc_hd__dfrtp_1
X_1042_ _1485_/A _1485_/B VGND VGND VDPWR VDPWR _1132_/A sky130_fd_sc_hd__nor2_1
Xmax_cap1 _1583_/Y VGND VGND VDPWR VDPWR max_cap1/X sky130_fd_sc_hd__buf_6
X_2091_ clkload8/A _2091_/D VGND VGND VDPWR VDPWR _2091_/Q sky130_fd_sc_hd__dfxtp_1
X_1111_ _1121_/D _1278_/A _1348_/A VGND VGND VDPWR VDPWR _1115_/B sky130_fd_sc_hd__nor3_1
X_1944_ _1624_/B _1939_/Y _1943_/Y VGND VGND VDPWR VDPWR _1946_/A sky130_fd_sc_hd__o21ai_1
X_1875_ _1875_/A _1875_/B VGND VGND VDPWR VDPWR _1875_/Y sky130_fd_sc_hd__nand2_1
XTAP_TAPCELL_ROW_41_1_1_158 VGND VDPWR sky130_fd_sc_hd__tapvpwrvgnd_1
XFILLER_56_113 VGND VGND VDPWR VDPWR sky130_fd_sc_hd__decap_3
X_1309_ hold140/X _1267_/Y _1308_/X _1652_/S VGND VGND VDPWR VDPWR _2177_/D sky130_fd_sc_hd__o22ai_1
XFILLER_12_216 VGND VGND VDPWR VDPWR sky130_fd_sc_hd__decap_3
XFILLER_12_227 VGND VGND VDPWR VDPWR sky130_fd_sc_hd__decap_3
XFILLER_52_341 VGND VGND VDPWR VDPWR sky130_fd_sc_hd__decap_3
XFILLER_69_56 VGND VGND VDPWR VDPWR sky130_fd_sc_hd__fill_2
XFILLER_69_67 VGND VGND VDPWR VDPWR sky130_fd_sc_hd__decap_3
XFILLER_43_341 VGND VGND VDPWR VDPWR sky130_fd_sc_hd__decap_3
XFILLER_7_220 VGND VGND VDPWR VDPWR sky130_fd_sc_hd__fill_1
XFILLER_50_91 VGND VGND VDPWR VDPWR sky130_fd_sc_hd__decap_3
X_1660_ _1673_/A _1660_/B VGND VGND VDPWR VDPWR _2052_/D sky130_fd_sc_hd__nor2_1
X_1591_ _2087_/Q _1590_/B _1590_/Y VGND VGND VDPWR VDPWR _1827_/C sky130_fd_sc_hd__o21a_1
X_2212_ _2213_/CLK wire70/X VGND VGND VDPWR VDPWR _2220_/D sky130_fd_sc_hd__dfxtp_1
X_2143_ _2160_/CLK _2143_/D VGND VGND VDPWR VDPWR _2143_/Q sky130_fd_sc_hd__dfxtp_1
XFILLER_34_341 VGND VGND VDPWR VDPWR sky130_fd_sc_hd__decap_3
XFILLER_61_171 VGND VGND VDPWR VDPWR sky130_fd_sc_hd__decap_3
XTAP_TAPCELL_ROW_26_2_2_148 VGND VDPWR sky130_fd_sc_hd__tapvpwrvgnd_1
X_1025_ _2075_/Q _1397_/A VGND VGND VDPWR VDPWR _1894_/A sky130_fd_sc_hd__nand2_1
X_2074_ clkload8/A _2074_/D VGND VGND VDPWR VDPWR _2074_/Q sky130_fd_sc_hd__dfxtp_1
X_1927_ _1676_/B _1941_/A _1926_/Y VGND VGND VDPWR VDPWR _1928_/C sky130_fd_sc_hd__a21oi_1
X_1858_ _1950_/A _1814_/A _1789_/Y VGND VGND VDPWR VDPWR _1858_/Y sky130_fd_sc_hd__a21oi_1
XPHY_EDGE_ROW_80_Right_99 VGND VDPWR sky130_fd_sc_hd__tapvpwrvgnd_1
X_1789_ uio_in[3] wire97/X _1783_/Y wire76/X VGND VGND VDPWR VDPWR _1789_/Y sky130_fd_sc_hd__o22ai_1
XFILLER_71_13 VGND VGND VDPWR VDPWR sky130_fd_sc_hd__decap_3
XFILLER_71_35 VGND VGND VDPWR VDPWR sky130_fd_sc_hd__decap_3
XFILLER_4_234 VGND VGND VDPWR VDPWR sky130_fd_sc_hd__fill_2
XPHY_EDGE_ROW_42_Left_101 VGND VDPWR sky130_fd_sc_hd__tapvpwrvgnd_1
XFILLER_43_171 VGND VGND VDPWR VDPWR sky130_fd_sc_hd__fill_2
XFILLER_43_182 VGND VGND VDPWR VDPWR sky130_fd_sc_hd__decap_3
XPHY_EDGE_ROW_51_Left_110 VGND VDPWR sky130_fd_sc_hd__tapvpwrvgnd_1
XANTENNA_1 _1956_/A1 VGND VGND VDPWR VDPWR sky130_fd_sc_hd__diode_2
X_1712_ _2044_/A _1714_/C VGND VGND VDPWR VDPWR _1712_/Y sky130_fd_sc_hd__nand2_1
X_1643_ _2179_/Q _1587_/A _1646_/S VGND VGND VDPWR VDPWR _2191_/D sky130_fd_sc_hd__mux2_1
XFILLER_58_208 VGND VGND VDPWR VDPWR sky130_fd_sc_hd__decap_3
X_1574_ _1771_/A _1790_/B _1566_/Y VGND VGND VDPWR VDPWR _1574_/Y sky130_fd_sc_hd__o21ai_1
Xu_sub.u_core.u_regfile.g_nibsel\[3\].g_nib\[1\].u_lo u_sub.u_core.u_regfile.g_word\[3\].g_byte\[0\].u_lat/Q1
+ u_sub.u_core.u_regfile.g_word\[3\].g_byte\[0\].u_lat/Q5 u_sub.u_core.u_regfile.g_word\[3\].g_byte\[1\].u_lat/Q1
+ u_sub.u_core.u_regfile.g_word\[3\].g_byte\[1\].u_lat/Q5 max_cap4/X max_cap3/X VGND
+ VGND VDPWR VDPWR u_sub.u_core.u_regfile.g_nibsel\[3\].g_nib\[1\].u_lo/X tg_mux4_x1
X_2126_ clkload9/A _2126_/D VGND VGND VDPWR VDPWR _2126_/Q sky130_fd_sc_hd__dfxtp_1
X_2057_ _2151_/CLK _2057_/D VGND VGND VDPWR VDPWR _2057_/Q sky130_fd_sc_hd__dfxtp_1
XFILLER_41_38 VGND VGND VDPWR VDPWR sky130_fd_sc_hd__decap_3
X_1008_ _2078_/Q VGND VGND VDPWR VDPWR _1749_/A sky130_fd_sc_hd__inv_1
Xclkbuf_1_1__f_u_sub.u_timer.g_cmp\[0\].g clkbuf_0_u_sub.u_timer.g_cmp\[0\].g/X VGND
+ VGND VDPWR VDPWR _2218_/GATE sky130_fd_sc_hd__clkbuf_2
XFILLER_40_141 VGND VGND VDPWR VDPWR sky130_fd_sc_hd__decap_3
XFILLER_40_152 VGND VGND VDPWR VDPWR sky130_fd_sc_hd__decap_3
XTAP_TAPCELL_ROW_42_169 VGND VDPWR sky130_fd_sc_hd__tapvpwrvgnd_1
Xu_sub.u_core.u_regfile.g_nibsel\[1\].g_nib\[0\].u_hi u_sub.u_core.u_regfile.g_word\[1\].g_byte\[2\].u_lat/Q0
+ u_sub.u_core.u_regfile.g_word\[1\].g_byte\[2\].u_lat/Q4 u_sub.u_core.u_regfile.g_word\[1\].g_byte\[3\].u_lat/Q0
+ u_sub.u_core.u_regfile.g_word\[1\].g_byte\[3\].u_lat/Q4 wire83/X max_cap82/X VGND
+ VGND VDPWR VDPWR u_sub.u_core.u_regfile.g_nibsel\[1\].g_nib\[0\].u_hi/X tg_mux4_x1
XFILLER_48_230 VGND VGND VDPWR VDPWR sky130_fd_sc_hd__decap_3
X_1290_ _1282_/B _1021_/Y _1242_/A _2077_/Q VGND VGND VDPWR VDPWR _1290_/Y sky130_fd_sc_hd__a31oi_1
XFILLER_63_277 VGND VGND VDPWR VDPWR sky130_fd_sc_hd__fill_1
X_1626_ _2112_/Q _1624_/A _1588_/B _2137_/Q VGND VGND VDPWR VDPWR _1627_/B sky130_fd_sc_hd__a22oi_1
X_1557_ _2089_/Q _1278_/A _1590_/B VGND VGND VDPWR VDPWR _1559_/B sky130_fd_sc_hd__mux2_1
X_1488_ _1584_/A _1138_/B _1584_/C _1471_/B VGND VGND VDPWR VDPWR _1488_/X sky130_fd_sc_hd__o31a_1
XTAP_TAPCELL_ROW_56_239 VGND VDPWR sky130_fd_sc_hd__tapvpwrvgnd_1
X_2109_ clkload5/A _2109_/D VGND VGND VDPWR VDPWR _2109_/Q sky130_fd_sc_hd__dfxtp_1
XFILLER_60_203 VGND VGND VDPWR VDPWR sky130_fd_sc_hd__fill_1
XFILLER_60_214 VGND VGND VDPWR VDPWR sky130_fd_sc_hd__fill_2
X_1411_ _1057_/B _1586_/A _1516_/A VGND VGND VDPWR VDPWR _1412_/B sky130_fd_sc_hd__a21oi_1
X_1342_ _1080_/Y _1795_/A _1341_/Y VGND VGND VDPWR VDPWR _1342_/Y sky130_fd_sc_hd__a21oi_1
X_1273_ _1600_/A1 _1647_/B _1098_/Y _2165_/Q VGND VGND VDPWR VDPWR _1273_/Y sky130_fd_sc_hd__o22ai_1
XTAP_TAPCELL_ROW_61_264 VGND VDPWR sky130_fd_sc_hd__tapvpwrvgnd_1
X_1609_ _2083_/Q _1827_/A VGND VGND VDPWR VDPWR _1609_/Y sky130_fd_sc_hd__nand2_1
XFILLER_27_200 VGND VGND VDPWR VDPWR sky130_fd_sc_hd__fill_1
XFILLER_27_222 VGND VGND VDPWR VDPWR sky130_fd_sc_hd__fill_2
XTAP_TAPCELL_ROW_52_220 VGND VDPWR sky130_fd_sc_hd__tapvpwrvgnd_1
XFILLER_10_188 VGND VGND VDPWR VDPWR sky130_fd_sc_hd__decap_3
XFILLER_18_200 VGND VGND VDPWR VDPWR sky130_fd_sc_hd__decap_3
XTAP_TAPCELL_ROW_75_334 VGND VDPWR sky130_fd_sc_hd__tapvpwrvgnd_1
XFILLER_41_280 VGND VGND VDPWR VDPWR sky130_fd_sc_hd__decap_3
X_1960_ _1959_/A hold65/A _1939_/Y _1959_/Y VGND VGND VDPWR VDPWR _1963_/B sky130_fd_sc_hd__a211oi_1
X_1891_ _2111_/Q _1881_/X _1729_/A VGND VGND VDPWR VDPWR _1892_/B sky130_fd_sc_hd__o21ai_1
XTAP_TAPCELL_ROW_34_2_2_152 VGND VDPWR sky130_fd_sc_hd__tapvpwrvgnd_1
X_1325_ _1153_/D _1280_/B _1746_/A VGND VGND VDPWR VDPWR _1326_/B sky130_fd_sc_hd__a21oi_1
X_1256_ _1256_/A _1256_/B VGND VGND VDPWR VDPWR _1257_/B sky130_fd_sc_hd__nand2_1
X_1187_ _1512_/B _1498_/A _1169_/Y _1166_/A _1841_/S VGND VGND VDPWR VDPWR _1187_/X
+ sky130_fd_sc_hd__a221o_1
XFILLER_58_69 VGND VGND VDPWR VDPWR sky130_fd_sc_hd__fill_1
XFILLER_15_225 VGND VGND VDPWR VDPWR sky130_fd_sc_hd__fill_1
XFILLER_59_188 VGND VGND VDPWR VDPWR sky130_fd_sc_hd__fill_1
Xu_sub.u_psram.u_cg_sck.u_icg delaybuf_14_clk/X _1914_/B VGND VGND VDPWR VDPWR _2234_/A
+ sky130_fd_sc_hd__dlclkp_1
XFILLER_65_103 VGND VGND VDPWR VDPWR sky130_fd_sc_hd__fill_2
X_2090_ clkload5/A _2090_/D VGND VGND VDPWR VDPWR _2090_/Q sky130_fd_sc_hd__dfxtp_1
X_1110_ wire70/X _1567_/B _1110_/C VGND VGND VDPWR VDPWR _1199_/A sky130_fd_sc_hd__and3_1
X_1041_ _1124_/C _1104_/B VGND VGND VDPWR VDPWR _1485_/B sky130_fd_sc_hd__nand2b_1
Xmax_cap2 max_cap3/X VGND VGND VDPWR VDPWR max_cap2/X sky130_fd_sc_hd__buf_4
X_1943_ _1963_/A _1943_/B _1943_/C VGND VGND VDPWR VDPWR _1943_/Y sky130_fd_sc_hd__nor3_1
X_1874_ _2111_/Q _1881_/D VGND VGND VDPWR VDPWR _1875_/B sky130_fd_sc_hd__nand2_1
XTAP_TAPCELL_ROW_41_1_1_159 VGND VDPWR sky130_fd_sc_hd__tapvpwrvgnd_1
XFILLER_56_125 VGND VGND VDPWR VDPWR sky130_fd_sc_hd__fill_2
XFILLER_56_169 VGND VGND VDPWR VDPWR sky130_fd_sc_hd__decap_3
Xu_sub.u_core.u_regfile.g_nibsel\[4\].g_nib\[3\].u_m2 u_sub.u_core.u_regfile.g_nibsel\[4\].g_nib\[3\].u_lo/X
+ u_sub.u_core.u_regfile.g_nibsel\[4\].g_nib\[3\].u_hi/X max_cap1/X VGND VGND VDPWR
+ VDPWR u_sub.u_core.u_regfile.g_port\[3\].u_b/A3 sky130_fd_sc_hd__mux2_1
X_1308_ wire89/X _1306_/Y _1307_/Y _1268_/Y VGND VGND VDPWR VDPWR _1308_/X sky130_fd_sc_hd__o31a_1
X_1239_ _1242_/B _1237_/Y _1238_/Y VGND VGND VDPWR VDPWR _1239_/Y sky130_fd_sc_hd__a21oi_1
XFILLER_69_13 VGND VGND VDPWR VDPWR sky130_fd_sc_hd__decap_3
XFILLER_69_35 VGND VGND VDPWR VDPWR sky130_fd_sc_hd__decap_3
XFILLER_47_103 VGND VGND VDPWR VDPWR sky130_fd_sc_hd__decap_3
Xclkbuf_1_0__f_u_sub.u_core.pc_gclk clkbuf_0_u_sub.u_core.pc_gclk/X VGND VGND VDPWR
+ VDPWR _2178_/CLK sky130_fd_sc_hd__clkbuf_2
XFILLER_43_320 VGND VGND VDPWR VDPWR sky130_fd_sc_hd__fill_1
XFILLER_47_147 VGND VGND VDPWR VDPWR sky130_fd_sc_hd__decap_3
XFILLER_62_117 VGND VGND VDPWR VDPWR sky130_fd_sc_hd__decap_3
Xwire130 _2057_/Q VGND VGND VDPWR VDPWR wire130/X sky130_fd_sc_hd__buf_12
X_1590_ _1166_/A _1590_/B VGND VGND VDPWR VDPWR _1590_/Y sky130_fd_sc_hd__nand2b_1
XFILLER_53_117 VGND VGND VDPWR VDPWR sky130_fd_sc_hd__fill_1
X_1024_ _1747_/A _1024_/B VGND VGND VDPWR VDPWR _1723_/B sky130_fd_sc_hd__nor2_1
X_2211_ clkload9/A hold21/A VGND VGND VDPWR VDPWR _2232_/A sky130_fd_sc_hd__dfxtp_1
X_2142_ _2160_/CLK _2142_/D VGND VGND VDPWR VDPWR _2142_/Q sky130_fd_sc_hd__dfxtp_1
X_2073_ _2160_/CLK _2073_/D _2044_/A VGND VGND VDPWR VDPWR _2073_/Q sky130_fd_sc_hd__dfrtp_1
XFILLER_61_183 VGND VGND VDPWR VDPWR sky130_fd_sc_hd__decap_3
XFILLER_61_194 VGND VGND VDPWR VDPWR sky130_fd_sc_hd__decap_3
XTAP_TAPCELL_ROW_48_197 VGND VDPWR sky130_fd_sc_hd__tapvpwrvgnd_1
X_1926_ _2124_/Q _1932_/B _1941_/A _1923_/Y VGND VGND VDPWR VDPWR _1926_/Y sky130_fd_sc_hd__o22ai_1
X_1857_ _2085_/Q _1822_/X _1856_/Y _1586_/A VGND VGND VDPWR VDPWR _1857_/Y sky130_fd_sc_hd__o211ai_1
X_1788_ _1785_/Y _1786_/Y _1787_/Y _1784_/Y _1849_/A VGND VGND VDPWR VDPWR wire77/A
+ sky130_fd_sc_hd__a311oi_1
XFILLER_40_323 VGND VGND VDPWR VDPWR sky130_fd_sc_hd__fill_1
XFILLER_52_194 VGND VGND VDPWR VDPWR sky130_fd_sc_hd__fill_2
XFILLER_71_25 VGND VGND VDPWR VDPWR sky130_fd_sc_hd__decap_3
XFILLER_71_47 VGND VGND VDPWR VDPWR sky130_fd_sc_hd__decap_3
Xhold60 hold60/A VGND VGND VDPWR VDPWR hold60/X sky130_fd_sc_hd__dlygate4sd3_1
Xu_sub.u_core.u_regfile.g_port\[0\].u_za u_sub.u_core.u_regfile.g_port\[0\].u_a/X
+ _1154_/Y VGND VGND VDPWR VDPWR _1764_/A1 sky130_fd_sc_hd__and2_1
XFILLER_28_191 VGND VGND VDPWR VDPWR sky130_fd_sc_hd__decap_3
XANTENNA_2 _2215_/D VGND VGND VDPWR VDPWR sky130_fd_sc_hd__diode_2
X_1711_ _2064_/Q _2065_/Q _1711_/C VGND VGND VDPWR VDPWR _1714_/C sky130_fd_sc_hd__nand3_1
X_1642_ _1641_/A _2046_/A _1641_/C _1524_/A _1017_/Y VGND VGND VDPWR VDPWR _2093_/D
+ sky130_fd_sc_hd__o32ai_1
X_1573_ _1827_/A _1573_/B VGND VGND VDPWR VDPWR _1790_/B sky130_fd_sc_hd__xnor2_1
XFILLER_19_191 VGND VGND VDPWR VDPWR sky130_fd_sc_hd__decap_3
XFILLER_41_109 VGND VGND VDPWR VDPWR sky130_fd_sc_hd__decap_3
X_1007_ _2150_/Q VGND VGND VDPWR VDPWR _1007_/Y sky130_fd_sc_hd__inv_1
X_2125_ clkload9/A _2125_/D VGND VGND VDPWR VDPWR _2125_/Q sky130_fd_sc_hd__dfxtp_1
X_2056_ _2151_/CLK _2056_/D VGND VGND VDPWR VDPWR _2056_/Q sky130_fd_sc_hd__dfxtp_1
XFILLER_41_28 VGND VGND VDPWR VDPWR sky130_fd_sc_hd__decap_3
X_1909_ _2116_/Q _1487_/C _2044_/A VGND VGND VDPWR VDPWR _1909_/Y sky130_fd_sc_hd__o21ai_1
XTAP_TAPCELL_ROW_67_292 VGND VDPWR sky130_fd_sc_hd__tapvpwrvgnd_1
XFILLER_40_175 VGND VGND VDPWR VDPWR sky130_fd_sc_hd__fill_1
XFILLER_48_242 VGND VGND VDPWR VDPWR sky130_fd_sc_hd__decap_3
XFILLER_68_1 VGND VGND VDPWR VDPWR sky130_fd_sc_hd__decap_3
X_1625_ _2037_/B _2037_/C VGND VGND VDPWR VDPWR _1844_/B sky130_fd_sc_hd__nor2_1
X_1556_ _1556_/A0 _1556_/A1 ui_in[3] VGND VGND VDPWR VDPWR _1556_/X sky130_fd_sc_hd__mux2_1
XFILLER_39_231 VGND VGND VDPWR VDPWR sky130_fd_sc_hd__decap_3
XFILLER_39_242 VGND VGND VDPWR VDPWR sky130_fd_sc_hd__decap_3
XFILLER_39_264 VGND VGND VDPWR VDPWR sky130_fd_sc_hd__fill_1
XFILLER_39_275 VGND VGND VDPWR VDPWR sky130_fd_sc_hd__decap_3
X_1487_ _1472_/X _1487_/B _1487_/C VGND VGND VDPWR VDPWR _1487_/Y sky130_fd_sc_hd__nand3b_1
X_2108_ clkload4/A _2108_/D VGND VGND VDPWR VDPWR _2108_/Q sky130_fd_sc_hd__dfxtp_1
X_2039_ _2147_/Q _2039_/B _2039_/C VGND VGND VDPWR VDPWR _2039_/Y sky130_fd_sc_hd__nand3_1
XPHY_EDGE_ROW_70_Left_129 VGND VDPWR sky130_fd_sc_hd__tapvpwrvgnd_1
XFILLER_45_201 VGND VGND VDPWR VDPWR sky130_fd_sc_hd__fill_1
XFILLER_60_226 VGND VGND VDPWR VDPWR sky130_fd_sc_hd__decap_3
XFILLER_60_259 VGND VGND VDPWR VDPWR sky130_fd_sc_hd__fill_1
XPHY_EDGE_ROW_32_2_2_Right_51 VGND VDPWR sky130_fd_sc_hd__tapvpwrvgnd_1
X_1410_ _1410_/A _1410_/B wire92/X VGND VGND VDPWR VDPWR _1562_/B sky130_fd_sc_hd__nand3_1
XFILLER_68_337 VGND VGND VDPWR VDPWR sky130_fd_sc_hd__decap_3
X_1341_ _1302_/A _1338_/Y _1340_/Y VGND VGND VDPWR VDPWR _1341_/Y sky130_fd_sc_hd__o21ai_1
X_1272_ _1600_/A1 _1086_/X _1087_/Y _1271_/Y VGND VGND VDPWR VDPWR _1272_/Y sky130_fd_sc_hd__a22oi_1
XFILLER_51_237 VGND VGND VDPWR VDPWR sky130_fd_sc_hd__fill_1
XTAP_TAPCELL_ROW_61_265 VGND VDPWR sky130_fd_sc_hd__tapvpwrvgnd_1
X_1608_ _1608_/A1 _1598_/Y _1599_/Y VGND VGND VDPWR VDPWR _1823_/B sky130_fd_sc_hd__a21boi_1
X_1539_ _1539_/A _1539_/B VGND VGND VDPWR VDPWR _1543_/B sky130_fd_sc_hd__nand2_1
XFILLER_27_234 VGND VGND VDPWR VDPWR sky130_fd_sc_hd__fill_2
XFILLER_42_215 VGND VGND VDPWR VDPWR sky130_fd_sc_hd__fill_1
XFILLER_63_26 VGND VGND VDPWR VDPWR sky130_fd_sc_hd__decap_3
XTAP_TAPCELL_ROW_52_221 VGND VDPWR sky130_fd_sc_hd__tapvpwrvgnd_1
XFILLER_18_234 VGND VGND VDPWR VDPWR sky130_fd_sc_hd__fill_2
XTAP_TAPCELL_ROW_75_335 VGND VDPWR sky130_fd_sc_hd__tapvpwrvgnd_1
X_1890_ _2215_/D _1890_/B VGND VGND VDPWR VDPWR _1892_/A sky130_fd_sc_hd__nor2_1
X_1324_ _1324_/A _1324_/B VGND VGND VDPWR VDPWR _1324_/Y sky130_fd_sc_hd__nand2_1
X_1255_ _1259_/A _1255_/B VGND VGND VDPWR VDPWR _1256_/B sky130_fd_sc_hd__or2_1
X_1186_ _1033_/C _1169_/A _1185_/Y _1179_/B _1791_/A VGND VGND VDPWR VDPWR _1186_/X
+ sky130_fd_sc_hd__a221o_1
XFILLER_24_215 VGND VGND VDPWR VDPWR sky130_fd_sc_hd__fill_1
XFILLER_59_112 VGND VGND VDPWR VDPWR sky130_fd_sc_hd__decap_3
XFILLER_59_134 VGND VGND VDPWR VDPWR sky130_fd_sc_hd__decap_3
XFILLER_15_215 VGND VGND VDPWR VDPWR sky130_fd_sc_hd__decap_3
XTAP_TAPCELL_ROW_80_360 VGND VDPWR sky130_fd_sc_hd__tapvpwrvgnd_1
XFILLER_65_115 VGND VGND VDPWR VDPWR sky130_fd_sc_hd__decap_3
X_1040_ _1153_/C _1151_/B _1350_/A _1316_/B VGND VGND VDPWR VDPWR _1123_/B sky130_fd_sc_hd__or4_1
Xmax_cap3 _1574_/Y VGND VGND VDPWR VDPWR max_cap3/X sky130_fd_sc_hd__buf_6
X_1942_ _1942_/A _1970_/B VGND VGND VDPWR VDPWR _1943_/C sky130_fd_sc_hd__nor2_1
XTAP_TAPCELL_ROW_38_2_2_154 VGND VDPWR sky130_fd_sc_hd__tapvpwrvgnd_1
X_1873_ _2105_/Q _1875_/A _1872_/Y _1729_/A VGND VGND VDPWR VDPWR _2105_/D sky130_fd_sc_hd__o211a_1
XFILLER_56_137 VGND VGND VDPWR VDPWR sky130_fd_sc_hd__decap_3
X_1307_ _2197_/Q _1471_/B VGND VGND VDPWR VDPWR _1307_/Y sky130_fd_sc_hd__nor2_1
X_1238_ _1174_/B _1174_/C _1566_/A VGND VGND VDPWR VDPWR _1238_/Y sky130_fd_sc_hd__o21ai_1
X_1169_ _1169_/A _1278_/B _1169_/C VGND VGND VDPWR VDPWR _1169_/Y sky130_fd_sc_hd__nor3_1
XFILLER_69_25 VGND VGND VDPWR VDPWR sky130_fd_sc_hd__decap_3
XFILLER_69_47 VGND VGND VDPWR VDPWR sky130_fd_sc_hd__decap_3
XFILLER_47_159 VGND VGND VDPWR VDPWR sky130_fd_sc_hd__decap_3
XFILLER_55_192 VGND VGND VDPWR VDPWR sky130_fd_sc_hd__fill_1
XFILLER_62_107 VGND VGND VDPWR VDPWR sky130_fd_sc_hd__fill_2
XFILLER_62_129 VGND VGND VDPWR VDPWR sky130_fd_sc_hd__decap_3
XFILLER_70_173 VGND VGND VDPWR VDPWR sky130_fd_sc_hd__decap_3
Xwire131 _2056_/Q VGND VGND VDPWR VDPWR wire131/X sky130_fd_sc_hd__buf_12
XFILLER_59_80 VGND VGND VDPWR VDPWR sky130_fd_sc_hd__decap_3
XFILLER_59_91 VGND VGND VDPWR VDPWR sky130_fd_sc_hd__fill_1
X_2210_ _2210_/CLK _2210_/D VGND VGND VDPWR VDPWR hold35/A sky130_fd_sc_hd__dfxtp_1
XFILLER_46_170 VGND VGND VDPWR VDPWR sky130_fd_sc_hd__decap_3
XTAP_TAPCELL_ROW_48_198 VGND VDPWR sky130_fd_sc_hd__tapvpwrvgnd_1
X_1023_ _1566_/A _2077_/Q VGND VGND VDPWR VDPWR _1442_/A sky130_fd_sc_hd__nor2_1
X_2141_ _2160_/CLK _2141_/D VGND VGND VDPWR VDPWR _2141_/Q sky130_fd_sc_hd__dfxtp_1
X_2072_ clkload6/A _2072_/D VGND VGND VDPWR VDPWR _2072_/Q sky130_fd_sc_hd__dfxtp_1
XFILLER_61_151 VGND VGND VDPWR VDPWR sky130_fd_sc_hd__decap_3
X_1925_ _2037_/B _1941_/A _1924_/Y VGND VGND VDPWR VDPWR _1928_/B sky130_fd_sc_hd__a21oi_1
XPHY_EDGE_ROW_29_2_2_Right_48 VGND VDPWR sky130_fd_sc_hd__tapvpwrvgnd_1
X_1856_ _1595_/Y _1818_/Y _1822_/X _1855_/Y VGND VGND VDPWR VDPWR _1856_/Y sky130_fd_sc_hd__o211ai_1
X_1787_ _2059_/Q wire7/X _1787_/C VGND VGND VDPWR VDPWR _1787_/Y sky130_fd_sc_hd__nand3_1
XFILLER_37_181 VGND VGND VDPWR VDPWR sky130_fd_sc_hd__decap_3
XFILLER_37_192 VGND VGND VDPWR VDPWR sky130_fd_sc_hd__decap_3
XFILLER_52_184 VGND VGND VDPWR VDPWR sky130_fd_sc_hd__fill_1
XFILLER_71_59 VGND VGND VDPWR VDPWR sky130_fd_sc_hd__decap_3
Xu_sub.u_core.u_regfile.g_port\[0\].u_zb u_sub.u_core.u_regfile.g_port\[0\].u_b/X
+ _1146_/X VGND VGND VDPWR VDPWR wire70/A sky130_fd_sc_hd__and2_1
Xhold50 hold50/A VGND VGND VDPWR VDPWR hold50/X sky130_fd_sc_hd__dlygate4sd3_1
Xhold61 hold61/A VGND VGND VDPWR VDPWR hold61/X sky130_fd_sc_hd__dlygate4sd3_1
XANTENNA_3 _2092_/Q VGND VGND VDPWR VDPWR sky130_fd_sc_hd__diode_2
X_1710_ _2065_/Q _1714_/B VGND VGND VDPWR VDPWR _1710_/Y sky130_fd_sc_hd__nand2_1
X_1641_ _1641_/A _2046_/A _1641_/C VGND VGND VDPWR VDPWR _2097_/D sky130_fd_sc_hd__nor3_1
X_1572_ _1572_/A _1572_/B VGND VGND VDPWR VDPWR _1573_/B sky130_fd_sc_hd__xnor2_1
X_2124_ clkload9/A _2124_/D VGND VGND VDPWR VDPWR _2124_/Q sky130_fd_sc_hd__dfxtp_1
X_1006_ _1006_/A VGND VGND VDPWR VDPWR _1006_/Y sky130_fd_sc_hd__inv_1
X_2055_ clkload7/A _2055_/D VGND VGND VDPWR VDPWR _2055_/Q sky130_fd_sc_hd__dfxtp_1
X_1908_ _2113_/Q _1908_/B _1908_/C VGND VGND VDPWR VDPWR _1908_/Y sky130_fd_sc_hd__nand3_1
X_1839_ _1839_/A _1839_/B _1839_/C VGND VGND VDPWR VDPWR _2046_/B sky130_fd_sc_hd__and3_1
XFILLER_57_232 VGND VGND VDPWR VDPWR sky130_fd_sc_hd__decap_3
XTAP_TAPCELL_ROW_67_293 VGND VDPWR sky130_fd_sc_hd__tapvpwrvgnd_1
XFILLER_40_110 VGND VGND VDPWR VDPWR sky130_fd_sc_hd__fill_2
XFILLER_40_132 VGND VGND VDPWR VDPWR sky130_fd_sc_hd__fill_1
Xu_sub.u_core.u_regfile.g_nibsel\[1\].g_nib\[0\].u_lo u_sub.u_core.u_regfile.g_word\[1\].g_byte\[0\].u_lat/Q0
+ u_sub.u_core.u_regfile.g_word\[1\].g_byte\[0\].u_lat/Q4 u_sub.u_core.u_regfile.g_word\[1\].g_byte\[1\].u_lat/Q0
+ u_sub.u_core.u_regfile.g_word\[1\].g_byte\[1\].u_lat/Q4 wire83/X max_cap82/X VGND
+ VGND VDPWR VDPWR u_sub.u_core.u_regfile.g_nibsel\[1\].g_nib\[0\].u_lo/X tg_mux4_x1
XFILLER_48_221 VGND VGND VDPWR VDPWR sky130_fd_sc_hd__decap_3
XFILLER_48_254 VGND VGND VDPWR VDPWR sky130_fd_sc_hd__fill_1
XPHY_EDGE_ROW_59_Right_78 VGND VDPWR sky130_fd_sc_hd__tapvpwrvgnd_1
X_1624_ _1624_/A _1624_/B VGND VGND VDPWR VDPWR _2037_/C sky130_fd_sc_hd__nand2_1
X_1555_ _1841_/S _1555_/B VGND VGND VDPWR VDPWR _1555_/Y sky130_fd_sc_hd__nor2_1
XFILLER_39_210 VGND VGND VDPWR VDPWR sky130_fd_sc_hd__fill_1
XPHY_EDGE_ROW_68_Right_87 VGND VDPWR sky130_fd_sc_hd__tapvpwrvgnd_1
X_2107_ clkload4/A _2107_/D VGND VGND VDPWR VDPWR _2107_/Q sky130_fd_sc_hd__dfxtp_1
X_1486_ _1756_/B wire85/X _2038_/A VGND VGND VDPWR VDPWR _1486_/Y sky130_fd_sc_hd__o21ai_1
XPHY_EDGE_ROW_77_Right_96 VGND VDPWR sky130_fd_sc_hd__tapvpwrvgnd_1
X_2038_ _2038_/A _2043_/D VGND VGND VDPWR VDPWR _2039_/C sky130_fd_sc_hd__nand2_1
XPHY_EDGE_ROW_13_2_2_Right_32 VGND VDPWR sky130_fd_sc_hd__tapvpwrvgnd_1
Xdelaybuf_0_clk delaybuf_3_clk/X VGND VGND VDPWR VDPWR delaybuf_1_clk/A sky130_fd_sc_hd__clkbuf_2
XFILLER_45_268 VGND VGND VDPWR VDPWR sky130_fd_sc_hd__decap_3
XFILLER_60_205 VGND VGND VDPWR VDPWR sky130_fd_sc_hd__decap_3
Xu_sub.u_core.u_regfile.g_word\[1\].g_byte\[1\].u_lat max_cap121/X max_cap119/X wire116/A
+ max_cap115/X wire112/A max_cap111/X max_cap109/X _2100_/Q u_sub.u_core.u_regfile.g_word\[1\].g_byte\[1\].u_lat/GATE
+ VGND VDPWR u_sub.u_core.u_regfile.g_word\[1\].g_byte\[1\].u_lat/Q0 u_sub.u_core.u_regfile.g_word\[1\].g_byte\[1\].u_lat/Q1
+ u_sub.u_core.u_regfile.g_word\[1\].g_byte\[1\].u_lat/Q2 u_sub.u_core.u_regfile.g_word\[1\].g_byte\[1\].u_lat/Q3
+ u_sub.u_core.u_regfile.g_word\[1\].g_byte\[1\].u_lat/Q4 u_sub.u_core.u_regfile.g_word\[1\].g_byte\[1\].u_lat/Q5
+ u_sub.u_core.u_regfile.g_word\[1\].g_byte\[1\].u_lat/Q6 u_sub.u_core.u_regfile.g_word\[1\].g_byte\[1\].u_lat/Q7
+ dlxtp8_x1
X_1340_ _1301_/A _1339_/Y _1337_/Y VGND VGND VDPWR VDPWR _1340_/Y sky130_fd_sc_hd__a21oi_1
XFILLER_36_202 VGND VGND VDPWR VDPWR sky130_fd_sc_hd__fill_2
X_1271_ _1271_/A _1271_/B VGND VGND VDPWR VDPWR _1271_/Y sky130_fd_sc_hd__nand2_1
XFILLER_51_227 VGND VGND VDPWR VDPWR sky130_fd_sc_hd__fill_2
XTAP_TAPCELL_ROW_61_266 VGND VDPWR sky130_fd_sc_hd__tapvpwrvgnd_1
XFILLER_59_327 VGND VGND VDPWR VDPWR sky130_fd_sc_hd__fill_2
X_1607_ _1827_/C _1819_/B _1606_/Y VGND VGND VDPWR VDPWR _1607_/Y sky130_fd_sc_hd__o21ai_1
X_1538_ _1553_/A _1538_/B VGND VGND VDPWR VDPWR _1538_/Y sky130_fd_sc_hd__nor2_1
X_1469_ _2150_/Q _1469_/B VGND VGND VDPWR VDPWR _1477_/A sky130_fd_sc_hd__nand2_1
XFILLER_42_205 VGND VGND VDPWR VDPWR sky130_fd_sc_hd__decap_3
XFILLER_63_38 VGND VGND VDPWR VDPWR sky130_fd_sc_hd__fill_1
XTAP_TAPCELL_ROW_75_336 VGND VDPWR sky130_fd_sc_hd__tapvpwrvgnd_1
XFILLER_33_249 VGND VGND VDPWR VDPWR sky130_fd_sc_hd__fill_2
Xclkbuf_3_7__f_clk_regs clkbuf_0_clk_regs/X VGND VGND VDPWR VDPWR _2160_/CLK sky130_fd_sc_hd__clkbuf_2
XFILLER_5_194 VGND VGND VDPWR VDPWR sky130_fd_sc_hd__fill_1
X_1323_ _1166_/A _1169_/C _1170_/Y _1142_/B _1512_/B _1053_/B VGND VGND VDPWR VDPWR
+ _1324_/B sky130_fd_sc_hd__a222oi_1
XFILLER_56_308 VGND VGND VDPWR VDPWR sky130_fd_sc_hd__fill_1
X_1254_ _1259_/A _1255_/B VGND VGND VDPWR VDPWR _1256_/A sky130_fd_sc_hd__nand2_1
X_1185_ _1169_/A _1278_/B _1174_/C VGND VGND VDPWR VDPWR _1185_/Y sky130_fd_sc_hd__o21ai_1
Xu_sub.u_core.u_regfile.g_word\[4\].g_byte\[1\].u_cg.u_icg clkbuf_leaf_2_clk/X _1546_/Y
+ VGND VGND VDPWR VDPWR u_sub.u_core.u_regfile.g_word\[4\].g_byte\[1\].u_lat/GATE
+ sky130_fd_sc_hd__dlclkp_1
XFILLER_59_168 VGND VGND VDPWR VDPWR sky130_fd_sc_hd__fill_2
Xu_sub.u_core.u_regfile.g_word\[2\].g_byte\[3\].u_cg.u_icg clkbuf_leaf_0_clk/X _1538_/Y
+ VGND VGND VDPWR VDPWR u_sub.u_core.u_regfile.g_word\[2\].g_byte\[3\].u_lat/GATE
+ sky130_fd_sc_hd__dlclkp_1
XFILLER_70_344 VGND VGND VDPWR VDPWR sky130_fd_sc_hd__fill_1
XTAP_TAPCELL_ROW_72_317 VGND VDPWR sky130_fd_sc_hd__tapvpwrvgnd_1
XTAP_TAPCELL_ROW_80_361 VGND VDPWR sky130_fd_sc_hd__tapvpwrvgnd_1
XFILLER_2_197 VGND VGND VDPWR VDPWR sky130_fd_sc_hd__decap_3
XFILLER_38_308 VGND VGND VDPWR VDPWR sky130_fd_sc_hd__fill_2
XFILLER_48_93 VGND VGND VDPWR VDPWR sky130_fd_sc_hd__decap_3
XFILLER_65_149 VGND VGND VDPWR VDPWR sky130_fd_sc_hd__decap_3
Xmax_cap4 max_cap5/X VGND VGND VDPWR VDPWR max_cap4/X sky130_fd_sc_hd__buf_12
X_1941_ _1941_/A _1941_/B VGND VGND VDPWR VDPWR _1943_/B sky130_fd_sc_hd__nor2_1
X_1872_ _1875_/A _1872_/B VGND VGND VDPWR VDPWR _1872_/Y sky130_fd_sc_hd__nand2_1
XFILLER_43_1 VGND VGND VDPWR VDPWR sky130_fd_sc_hd__fill_2
XFILLER_56_116 VGND VGND VDPWR VDPWR sky130_fd_sc_hd__fill_2
X_1306_ _1343_/B _1833_/A VGND VGND VDPWR VDPWR _1306_/Y sky130_fd_sc_hd__nor2_1
XFILLER_52_344 VGND VGND VDPWR VDPWR sky130_fd_sc_hd__fill_1
X_1237_ _1841_/S _1142_/A _1236_/Y VGND VGND VDPWR VDPWR _1237_/Y sky130_fd_sc_hd__a21oi_1
X_1168_ _1167_/A _1167_/B _1174_/C VGND VGND VDPWR VDPWR _1168_/Y sky130_fd_sc_hd__o21ai_1
X_1099_ _1764_/A1 _1646_/S _1314_/B _2163_/Q VGND VGND VDPWR VDPWR _1099_/Y sky130_fd_sc_hd__a22oi_1
XFILLER_12_219 VGND VGND VDPWR VDPWR sky130_fd_sc_hd__decap_3
XFILLER_43_344 VGND VGND VDPWR VDPWR sky130_fd_sc_hd__fill_1
XFILLER_50_83 VGND VGND VDPWR VDPWR sky130_fd_sc_hd__decap_3
XFILLER_50_94 VGND VGND VDPWR VDPWR sky130_fd_sc_hd__fill_2
Xwire132 _2055_/Q VGND VGND VDPWR VDPWR wire132/X sky130_fd_sc_hd__buf_12
Xu_sub.u_core.u_regfile.g_nibsel\[2\].g_nib\[2\].u_m2 u_sub.u_core.u_regfile.g_nibsel\[2\].g_nib\[2\].u_lo/X
+ u_sub.u_core.u_regfile.g_nibsel\[2\].g_nib\[2\].u_hi/X max_cap1/X VGND VGND VDPWR
+ VDPWR u_sub.u_core.u_regfile.g_port\[2\].u_b/A1 sky130_fd_sc_hd__mux2_1
X_2140_ _2160_/CLK _2140_/D VGND VGND VDPWR VDPWR _2140_/Q sky130_fd_sc_hd__dfxtp_1
XFILLER_34_344 VGND VGND VDPWR VDPWR sky130_fd_sc_hd__fill_1
XFILLER_38_149 VGND VGND VDPWR VDPWR sky130_fd_sc_hd__decap_3
XFILLER_46_160 VGND VGND VDPWR VDPWR sky130_fd_sc_hd__decap_3
XFILLER_53_108 VGND VGND VDPWR VDPWR sky130_fd_sc_hd__decap_3
XFILLER_61_130 VGND VGND VDPWR VDPWR sky130_fd_sc_hd__fill_2
XTAP_TAPCELL_ROW_48_199 VGND VDPWR sky130_fd_sc_hd__tapvpwrvgnd_1
X_1022_ _1570_/A _1841_/S VGND VGND VDPWR VDPWR _1024_/B sky130_fd_sc_hd__nand2_1
X_2071_ clkload7/A _2071_/D VGND VGND VDPWR VDPWR _2071_/Q sky130_fd_sc_hd__dfxtp_1
XFILLER_61_174 VGND VGND VDPWR VDPWR sky130_fd_sc_hd__decap_3
X_1924_ _2125_/Q _1921_/Y _1939_/B VGND VGND VDPWR VDPWR _1924_/Y sky130_fd_sc_hd__o21ai_1
X_1855_ _2084_/Q _1595_/B _1595_/Y _1825_/Y _1827_/D VGND VGND VDPWR VDPWR _1855_/Y
+ sky130_fd_sc_hd__o2111ai_1
X_1786_ _1174_/A _1786_/A2 _1429_/D VGND VGND VDPWR VDPWR _1786_/Y sky130_fd_sc_hd__o21ai_1
XFILLER_37_160 VGND VGND VDPWR VDPWR sky130_fd_sc_hd__decap_3
XFILLER_71_16 VGND VGND VDPWR VDPWR sky130_fd_sc_hd__decap_3
XFILLER_71_38 VGND VGND VDPWR VDPWR sky130_fd_sc_hd__decap_3
Xhold40 hold40/A VGND VGND VDPWR VDPWR hold40/X sky130_fd_sc_hd__dlygate4sd3_1
XFILLER_45_83 VGND VGND VDPWR VDPWR sky130_fd_sc_hd__decap_3
Xhold51 hold51/A VGND VGND VDPWR VDPWR hold51/X sky130_fd_sc_hd__dlygate4sd3_1
Xhold62 hold62/A VGND VGND VDPWR VDPWR hold62/X sky130_fd_sc_hd__dlygate4sd3_1
XFILLER_43_185 VGND VGND VDPWR VDPWR sky130_fd_sc_hd__decap_3
XANTENNA_4 _1414_/Y VGND VGND VDPWR VDPWR sky130_fd_sc_hd__diode_2
X_1640_ _1852_/A _1640_/B VGND VGND VDPWR VDPWR _1641_/C sky130_fd_sc_hd__nor2_1
X_1571_ _1569_/Y _1571_/B VGND VGND VDPWR VDPWR _1572_/B sky130_fd_sc_hd__nand2b_1
X_2123_ clkload9/A _2123_/D VGND VGND VDPWR VDPWR _2230_/A sky130_fd_sc_hd__dfxtp_1
XTAP_TAPCELL_ROW_44_180 VGND VDPWR sky130_fd_sc_hd__tapvpwrvgnd_1
X_1005_ _2075_/Q VGND VGND VDPWR VDPWR _1174_/A sky130_fd_sc_hd__inv_1
X_2054_ clkload6/A _2054_/D VGND VGND VDPWR VDPWR _2054_/Q sky130_fd_sc_hd__dfxtp_1
X_1907_ _1911_/C _1906_/Y _2044_/A VGND VGND VDPWR VDPWR _2115_/D sky130_fd_sc_hd__a21boi_1
X_1838_ _2084_/Q _1822_/X _1837_/Y VGND VGND VDPWR VDPWR _1839_/C sky130_fd_sc_hd__o21ai_1
X_1769_ _1771_/A _1825_/C _1768_/Y VGND VGND VDPWR VDPWR _2084_/D sky130_fd_sc_hd__o21ai_1
XFILLER_57_222 VGND VGND VDPWR VDPWR sky130_fd_sc_hd__fill_2
XTAP_TAPCELL_ROW_67_294 VGND VDPWR sky130_fd_sc_hd__tapvpwrvgnd_1
XFILLER_40_122 VGND VGND VDPWR VDPWR sky130_fd_sc_hd__decap_3
XFILLER_40_144 VGND VGND VDPWR VDPWR sky130_fd_sc_hd__fill_1
XFILLER_48_233 VGND VGND VDPWR VDPWR sky130_fd_sc_hd__fill_1
XTAP_TAPCELL_ROW_58_250 VGND VDPWR sky130_fd_sc_hd__tapvpwrvgnd_1
XFILLER_31_188 VGND VGND VDPWR VDPWR sky130_fd_sc_hd__fill_1
X_1623_ _1624_/B _2037_/B _1623_/C VGND VGND VDPWR VDPWR _1894_/D sky130_fd_sc_hd__nand3_1
X_1554_ _1791_/A _1555_/B VGND VGND VDPWR VDPWR _1554_/Y sky130_fd_sc_hd__nor2_1
X_1485_ _1485_/A _1485_/B _1485_/C _1584_/C VGND VGND VDPWR VDPWR wire85/A sky130_fd_sc_hd__nor4_1
.ends
